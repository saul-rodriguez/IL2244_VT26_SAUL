ADE simulation setup
Run mode: Single Run, Sweeps and Corners
Tests:
  CHARACTERIZATION:GM_ID_NMOS:1: CHARACTERIZATION/GM_ID_NMOS/schematic, simulator spectre
Global variables:
  L = 1u
  NF = 1
  W = 10u
  IDS = {From/To}Decade:1n:15:100u{From/To}
  VDS = 2
