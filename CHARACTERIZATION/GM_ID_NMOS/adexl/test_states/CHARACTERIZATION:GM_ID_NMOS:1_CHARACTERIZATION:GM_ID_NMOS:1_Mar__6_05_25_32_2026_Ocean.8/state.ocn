design( "CHARACTERIZATION" "GM_ID_NMOS" "schematic")
modelFile(
    '("/opt/pdk/ams/410/spectre/c35/soac/processOption.scs" "")
    '("/opt/pdk/ams/410/spectre/c35/soac/cmos53.scs" "cmostm")
    '("/opt/pdk/ams/410/spectre/c35/soac/res.scs" "restm")
    '("/opt/pdk/ams/410/spectre/c35/soac/cap.scs" "captm")
    '("/opt/pdk/ams/410/spectre/c35/soac/bip.scs" "biptm")
    '("/opt/pdk/ams/410/spectre/c35/soac/ind.scs" "indtm")
    '("/opt/pdk/ams/410/spectre/c35/soac/esddiode.scs" "esddiodetm")
)
definitionFile(
    "/opt/pdk/ams/410/spectre/c35/soac/soac.scs"
)
analysis('dc ?saveOppoint t  )
desVar(	  "IDS" 1.5e-05	)
desVar(	  "L" 2e-06	)
desVar(	  "NF" 5	)
desVar(	  "VDS" 1.5	)
desVar(	  "W" 1e-05	)
envOption(
	'analysisOrder  list("dc" "pz" "dcmatch" "stb" "tran" "envlp" "ac" "lf" "noise" "xf" "sp" "pss" "pac" "pstb" "pnoise" "pxf" "psp" "qpss" "qpac" "qpnoise" "qpxf" "qpsp" "hb" "hbac" "hbstb" "hbnoise" "hbxf" "sens" "acmatch")
)
saveOption( ?outputParamInfo t )
saveOption( ?elementInfo t )
saveOption( ?modelParamInfo t )
temp( 27 )
