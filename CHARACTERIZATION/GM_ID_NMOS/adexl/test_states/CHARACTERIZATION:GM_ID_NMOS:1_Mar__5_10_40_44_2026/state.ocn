design( "CHARACTERIZATION" "GM_ID_NMOS" "schematic")
modelFile(
    '("/opt/pdk/ams/410/spectre/c35/soac/processOption.scs" "")
    '("/opt/pdk/ams/410/spectre/c35/soac/cmos53.scs" "cmostm")
    '("/opt/pdk/ams/410/spectre/c35/soac/res.scs" "restm")
    '("/opt/pdk/ams/410/spectre/c35/soac/cap.scs" "captm")
    '("/opt/pdk/ams/410/spectre/c35/soac/bip.scs" "biptm")
    '("/opt/pdk/ams/410/spectre/c35/soac/ind.scs" "indtm")
    '("/opt/pdk/ams/410/spectre/c35/soac/esddiode.scs" "esddiodetm")
)
definitionFile(
    "/opt/pdk/ams/410/spectre/c35/soac/soac.scs"
)
analysis('dc ?saveOppoint t  )
desVar(	  "W" 8e-06	)
desVar(	  "VDS" 2.0	)
desVar(	  "NF" 8	)
desVar(	  "L" 1e-06	)
desVar(	  "IDS" 1e-06	)
envOption(
	'firstRun  t
)
saveOption( ?outputParamInfo t )
saveOption( ?elementInfo t )
saveOption( ?modelParamInfo t )
temp( 27 )
