ADE simulation setup
Run mode: Single Run, Sweeps and Corners
Tests:
  ECG_IA:ecg_vga_tb:1: ECG_IA/ecg_vga_tb/schematic, simulator spectre
    Outputs: /VOUT
Global variables:
  VDD = 3.3
