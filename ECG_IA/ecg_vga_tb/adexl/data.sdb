ADE simulation setup
Run mode: Single Run, Sweeps and Corners
Tests:
  ECG_IA:ecg_vga_tb:1: ECG_IA/ecg_vga_tb/schematic, simulator spectre
    Outputs: /VOUT; /VOUT2; Total noise
  Linearity (off): ECG_IA/ecg_vga_tb/schematic, simulator spectre
    Outputs: /VOUT; /VOUT2
  MC (off): ECG_IA/ecg_vga_tb/schematic, simulator spectre
    Outputs: /VOUT; /VOUT2; Total Noise
Global variables:
  VDD = 3.3
  S0 = 3.3
  S1 = 3.3
  S2 = 3.3
  VIN_STEP = 0 (off)
  VIN_AMP = 80m (off)
  VIN_FREQ = 1k
Corners (all switched off):
  model folders: /opt/pdk/ams/410/spectre/c35/soac
  every corner: /opt/pdk/ams/410/spectre/c35/soac/processOption.scs, /opt/pdk/ams/410/spectre/c35/soac/cmos53.scs[cmoswo cmoswp cmosws cmoswz], /opt/pdk/ams/410/spectre/c35/soac/res.scs[restm], /opt/pdk/ams/410/spectre/c35/soac/bip.scs[biptm], /opt/pdk/ams/410/spectre/c35/soac/ind.scs[indtm], /opt/pdk/ams/410/spectre/c35/soac/esddiode.scs[esddiodetm]
  CMOS (off): cap.scs[captm]
  CMOS_VDD (off): VDD=2.97 3.63; cap.scs[captm]
  CMOS_CAP_VDD (off): VDD=2.97 3.63; cap.scs[capwp capws]
  CMOS_CAP_VDD_TEMP: temperature=-40 85; VDD=2.97 3.63; cap.scs[capwp capws]
