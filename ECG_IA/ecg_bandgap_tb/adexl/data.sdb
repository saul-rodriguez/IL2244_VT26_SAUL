ADE simulation setup
Run mode: Single Run, Sweeps and Corners
Tests:
  ECG_IA:ecg_bandgap_tb:1: ECG_IA/ecg_bandgap_tb/schematic, simulator spectre
Global variables:
  VDD = 3.3
  VDD_PULSE = 0
  VDD_RISE = 1n
