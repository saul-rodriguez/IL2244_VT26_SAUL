ADE simulation setup
Test DC: ECG_IA/ecg_bandgap_tb/schematic, simulator spectre
  Models: /opt/pdk/ams/410/spectre/c35/processOption.scs, /opt/pdk/ams/410/spectre/c35/cmos53.scs[cmostm], /opt/pdk/ams/410/spectre/c35/res.scs[restm], /opt/pdk/ams/410/spectre/c35/cap.scs[captm], /opt/pdk/ams/410/spectre/c35/bip.scs[biptm], /opt/pdk/ams/410/spectre/c35/ind.scs[indtm], /opt/pdk/ams/410/spectre/c35/esddiode.scs[esddiodetm]
  Variables: VDD = 3.3; VDD_PULSE = 0; VDD_RISE = 1u
  Temperature: 27
  Simulator options: reltol=100e-6 homotopy=all limit=delta additionalArgs=enable_pre_ver=yes ignorezerovar=yes
  Files: definitions /opt/pdk/ams/410/spectre/c35/soac/soac.scs
  Analysis dc: sweep VDD start=0 stop=3.3 step=20m (saves the operating point)
  Output VDC("/BG_REF")
  Output v /BG_REF; dc (V) = v("/BG_REF" ?result "dc")
  Signals: /BG_REF
