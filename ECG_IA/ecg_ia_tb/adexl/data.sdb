ADE simulation setup
Run mode: Single Run, Sweeps and Corners
Tests:
  ECG_IA:ecg_ia_tb:1: ECG_IA/ecg_ia_tb/schematic, simulator spectre
    Outputs: /VOUT1; /I2/INT; /VDDA
  Noise (off): ECG_IA/ecg_ia_tb/schematic, simulator spectre
    Outputs: transient_noise
  MC (off): ECG_IA/ecg_ia_tb/schematic, simulator spectre
    Outputs: histogram2D(value(mag(VF("/VOUT")) 50) 10 "standard" "both" t); value(mag(VF("/VOUT")) 50)
Global variables:
  VCM_AC = 1
  VCM_DC = 1.6
  VDD = 3.3 (off)
  VIN_AC = 1
  VIN_DC = 0 (off)
  FC = 2k (off)
  VIN_AMP = 0 (off)
  VIN_FREQ = 0 (off)
  VIN_STEP = 0 (off)
  VDD_STEP = 0 (off)
Corners (all switched off):
  model folders: /opt/pdk/ams/410/spectre/c35/soac
  CMOS (off): processOption.scs, cmos53.scs[cmoswo cmoswp cmosws cmoswz], res.scs[restm], cap.scs[captm], bip.scs[biptm], ind.scs[indtm], esddiode.scs[esddiodetm]
  CMOS_VDD: VDD=2.97 3.63; processOption.scs, cmos53.scs[cmoswo cmoswp cmosws cmoswz], res.scs[restm], cap.scs[captm], bip.scs[biptm], ind.scs[indtm], esddiode.scs[esddiodetm]
