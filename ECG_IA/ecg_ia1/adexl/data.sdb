ADE simulation setup
Run mode: Single Run, Sweeps and Corners
Tests:
  ECG_IA:ecg_ia1:1: ECG_IA/ecg_ia1/schematic, simulator spectre
    Outputs: VDC("/VOUT")
Global variables:
  VCM_AC = 0
  VCM_DC = 1.6
  VIN_AC = 1
  VIN_DC = 0
Corners:
  model folders: /opt/pdk/ams/410/spectre/c35/soac
  C0 (off): processOption.scs, cmos53.scs[cmoswo cmoswp cmosws cmoswz], res.scs[restm], cap.scs[captm], bip.scs[biptm], ind.scs[indtm], esddiode.scs[esddiodetm]
