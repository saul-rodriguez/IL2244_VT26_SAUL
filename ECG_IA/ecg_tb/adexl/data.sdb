ADE simulation setup
Run mode: Single Run, Sweeps and Corners
Tests:
  ECG_IA:ecg_ia_tb:1 (off): ECG_IA/ecg_tb/schematic, simulator spectre
    Outputs: /I2/INT
  Noise: ECG_IA/ecg_tb/schematic, simulator spectre
    Outputs: transient_noise; /I2/INT
  MC (off): ECG_IA/ecg_ia_tb/schematic, simulator spectre
    Outputs: histogram2D(value(mag(VF("/VOUT")) 50) 10 "standard" "both" t); value(mag(VF("/VOUT")) 50)
Global variables:
  VCM_AC = 1
  VCM_DC = 1.6
  VDD = 3.3
  VIN_AC = 1
  VIN_DC = 0 (off)
  FC = 2k (off)
  VIN_AMP = 0 (off)
  VIN_FREQ = 0 (off)
  S0 = 3.3
  S1 = 3.3
  S2 = 3.3
  T0 = 0
  T1 = 0
  T2 = 0
Corners (all switched off):
  model folders: /opt/pdk/ams/410/spectre/c35/soac
  CMOS (off): processOption.scs, cmos53.scs[cmoswo cmoswp cmosws cmoswz], res.scs[restm], cap.scs[captm], bip.scs[biptm], ind.scs[indtm], esddiode.scs[esddiodetm]
  CMOS_VDD: VDD=2.97 3.63; processOption.scs, cmos53.scs[cmoswo cmoswp cmosws cmoswz], res.scs[restm], cap.scs[captm], bip.scs[biptm], ind.scs[indtm], esddiode.scs[esddiodetm]
