ADE simulation setup
Run mode: Single Run, Sweeps and Corners
Tests:
  VIN: ECG_IA/ecg_tb/schematic, simulator spectre
    Outputs: /I2/INT
  Noise (off): ECG_IA/ecg_tb/schematic, simulator spectre
    Outputs: transient_noise; /I2/INT
  MC (off): ECG_IA/ecg_ia_tb/schematic, simulator spectre
    Outputs: histogram2D(value(mag(VF("/VOUT")) 50) 10 "standard" "both" t); value(mag(VF("/VOUT")) 50); CM_GAIN_HISTO
Global variables:
  VCM_AC = 1
  VCM_DC = 1.6
  VDD = 3.3
  VIN_AC = 1
  VIN_DC = 0 (off)
  FC = 2k (off)
  VIN_AMP = 0 (off)
  VIN_FREQ = 0 (off)
  S0 = 3.3
  S1 = 3.3
  S2 = 3.3
  T0 = 0
  T1 = 0
  T2 = 0
  VDD_STEP = 0
  VIN_STEP = 0
Corners (all switched off):
  model folders: /opt/pdk/ams/410/spectre/c35/soac
  every corner: /opt/pdk/ams/410/spectre/c35/soac/processOption.scs, /opt/pdk/ams/410/spectre/c35/soac/cmos53.scs[cmoswo cmoswp cmosws cmoswz], /opt/pdk/ams/410/spectre/c35/soac/bip.scs[biptm], /opt/pdk/ams/410/spectre/c35/soac/ind.scs[indtm], /opt/pdk/ams/410/spectre/c35/soac/esddiode.scs[esddiodetm]
  CMOS (off): res.scs[restm], cap.scs[captm]
  CMOS_VDD (off): VDD=2.97 3.63; res.scs[restm], cap.scs[captm]
  CMOS_VDD_TEMP (off): temperature=-40 85; VDD=2.97 3.63; res.scs[restm], cap.scs[captm]
  CMOS_RES_VDD_TEMP: temperature=-40 85; VDD=2.97 3.63; res.scs[reswp resws], cap.scs[capwp capws]
