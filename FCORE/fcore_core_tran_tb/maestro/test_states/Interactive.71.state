ADE simulation setup
Test TRAN_VIN: FCORE/fcore_core_tran_tb/schematic, simulator spectre
  Models: /opt/pdk/ams/410/spectre/c35/processOption.scs, /opt/pdk/ams/410/spectre/c35/cmos53.scs[cmostm], /opt/pdk/ams/410/spectre/c35/res.scs[restm], /opt/pdk/ams/410/spectre/c35/cap.scs[captm], /opt/pdk/ams/410/spectre/c35/bip.scs[biptm], /opt/pdk/ams/410/spectre/c35/ind.scs[indtm], /opt/pdk/ams/410/spectre/c35/esddiode.scs[esddiodetm]
  Variables: VREF_SEL = 0; CM_PULSE = 0; VDD_PULSE = 0; VIN_PULSE = 0; F0 = 3.3; F1 = 3.3; F2 = 0; S0 = 1; S1 = 0; S2 = 0; VCM_AMP = 0; VIN_FREQ = 50; VIN_AMP = 0.8m; FC = 4k; VCM_AC = 0; VCM_DC = 1.6; VDD = 3.3; VIN_AC = 1; VIN_DC = 0
  Temperature: 27
  Simulator options: reltol=100e-6 homotopy=all limit=delta additionalArgs=enable_pre_ver=yes ignorezerovar=yes
  Files: definitions /opt/pdk/ams/410/spectre/c35/soac/soac.scs
  Analysis dc: (saves the operating point)
  Analysis tran: stop=100m errpreset=conservative
  Signals: /VOUT, /VCM, /VDDA
Test TRAN_VIN_PULSE: FCORE/fcore_core_tran_tb/schematic, simulator spectre
  Models: /opt/pdk/ams/410/spectre/c35/processOption.scs, /opt/pdk/ams/410/spectre/c35/cmos53.scs[cmostm], /opt/pdk/ams/410/spectre/c35/res.scs[restm], /opt/pdk/ams/410/spectre/c35/cap.scs[captm], /opt/pdk/ams/410/spectre/c35/bip.scs[biptm], /opt/pdk/ams/410/spectre/c35/ind.scs[indtm], /opt/pdk/ams/410/spectre/c35/esddiode.scs[esddiodetm]
  Variables: VREF_SEL = 0; CM_PULSE = 0; VDD_PULSE = 0; VIN_PULSE = 10m; F0 = 3.3; F1 = 3.3; F2 = 0; S0 = 1; S1 = 0; S2 = 0; VCM_AMP = 0; VIN_FREQ = 50; VIN_AMP = 0; FC = 4k; VCM_AC = 0; VCM_DC = 1.6; VDD = 3.3; VIN_AC = 1; VIN_DC = 0
  Temperature: 27
  Simulator options: reltol=100e-6 homotopy=all limit=delta additionalArgs=enable_pre_ver=yes ignorezerovar=yes
  Files: definitions /opt/pdk/ams/410/spectre/c35/soac/soac.scs
  Analysis dc: (saves the operating point)
  Analysis tran: stop=5000m errpreset=conservative
  Signals: /VOUT, /VCM, /VDDA
Test TRAN_VDD_PULSE: FCORE/fcore_core_tran_tb/schematic, simulator spectre
  Models: /opt/pdk/ams/410/spectre/c35/processOption.scs, /opt/pdk/ams/410/spectre/c35/cmos53.scs[cmostm], /opt/pdk/ams/410/spectre/c35/res.scs[restm], /opt/pdk/ams/410/spectre/c35/cap.scs[captm], /opt/pdk/ams/410/spectre/c35/bip.scs[biptm], /opt/pdk/ams/410/spectre/c35/ind.scs[indtm], /opt/pdk/ams/410/spectre/c35/esddiode.scs[esddiodetm]
  Variables: VREF_SEL = 0; CM_PULSE = 0; VDD_PULSE = 0.1; VIN_PULSE = 0; F0 = 3.3; F1 = 3.3; F2 = 0; S0 = 1; S1 = 0; S2 = 0; VCM_AMP = 0; VIN_FREQ = 50; VIN_AMP = 0; FC = 1000; VCM_AC = 0; VCM_DC = 1.6; VDD = 3.3; VIN_AC = 1; VIN_DC = 0
  Temperature: 27
  Simulator options: reltol=100e-6 homotopy=all limit=delta additionalArgs=enable_pre_ver=yes ignorezerovar=yes
  Files: definitions /opt/pdk/ams/410/spectre/c35/soac/soac.scs
  Analysis dc: (saves the operating point)
  Analysis tran: stop=10 errpreset=conservative
  Signals: /VOUT, /VCM, /VDDA
