ADE simulation setup
Run mode: Single Run, Sweeps and Corners
Tests:
  DIG_SPI_il2244_dig_tb_1: DIG_SPI/il2244_dig_tb/config_sch, simulator ams
    Outputs: /reset_l
