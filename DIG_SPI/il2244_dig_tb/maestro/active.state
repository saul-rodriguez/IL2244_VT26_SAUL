ADE simulation setup
Test DIG_SPI_il2244_dig_tb_1: DIG_SPI/il2244_dig_tb/config_sch, simulator ams
  Models: /opt/pdk/ams/410/spectre/c35/processOption.scs, /opt/pdk/ams/410/spectre/c35/cmos53.scs[cmostm], /opt/pdk/ams/410/spectre/c35/res.scs[restm], /opt/pdk/ams/410/spectre/c35/cap.scs[captm], /opt/pdk/ams/410/spectre/c35/bip.scs[biptm], /opt/pdk/ams/410/spectre/c35/ind.scs[indtm], /opt/pdk/ams/410/spectre/c35/esddiode.scs[esddiodetm]
  Temperature: 27
  Simulator options: reltol=100e-6 homotopy=all limit=delta additionalArgs=enable_pre_ver=yes ignorezerovar=yes
  Files: definitions /opt/pdk/ams/410/spectre/c35/soac/soac.scs
  Analysis tran: stop=0.65m errpreset=liberal
  Signals: /reset_l, /porborn, /SPI_CS, /SPI_Clk, /SPI_MOSI, /fECG_filter<2:0>, /fECG_gain<2:0>, /fECG_BG_sel, /BIO_Gain<3:0>, /Bio_Ptat_EN, /Bio_Calib_EN, /ECG_filter<2:0>, /ECG_gain<3:0>, /ECG_BG_sel
Run mode: Single Run, Sweeps and Corners
