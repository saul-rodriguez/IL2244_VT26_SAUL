ADE simulation setup
Run mode: Single Run, Sweeps and Corners
Tests:
  IL2244_VT26_LAYOUT_WS_opamp_ws_tb_1: IL2244_VT26_LAYOUT_WS/opamp_ws_tb/schematic, simulator spectre
    Variables: VDD = 3.3
    Outputs: /VOUT
