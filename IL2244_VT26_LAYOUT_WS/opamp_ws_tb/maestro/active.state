ADE simulation setup
Test IL2244_VT26_LAYOUT_WS_opamp_ws_tb_1: IL2244_VT26_LAYOUT_WS/opamp_ws_tb/schematic, simulator spectre
  Models: /opt/pdk/ams/410/spectre/c35/soac/processOption.scs, /opt/pdk/ams/410/spectre/c35/soac/cmos53.scs[cmostm], /opt/pdk/ams/410/spectre/c35/soac/res.scs[restm], /opt/pdk/ams/410/spectre/c35/soac/cap.scs[captm], /opt/pdk/ams/410/spectre/c35/soac/bip.scs[biptm], /opt/pdk/ams/410/spectre/c35/soac/ind.scs[indtm], /opt/pdk/ams/410/spectre/c35/soac/esddiode.scs[esddiodetm]
  Variables: VDD = 3.3
  Temperature: 27
  Simulator options: reltol=100e-6 homotopy=all limit=delta additionalArgs=enable_pre_ver=yes ignorezerovar=yes
  Files: definitions /opt/pdk/ams/410/spectre/c35/soac/soac.scs
  Analysis dc: (saves the operating point)
  Analysis pz: p=/VOUT iprobe=/V1 freq=1
  Analysis ac: start=0.01 stop=100M dec=30
  Output Poles = pzFrequencyAndRealFilter(getData("poles" ?result "pz"))
  Output Zeros = pzFrequencyAndRealFilter(getData("zeros" ?result "pz"))
  Signals: /VOUT
Run mode: Single Run, Sweeps and Corners
