ADE simulation setup
Test TRAN_VIN: YAOWEN/fecg_front_end_tran_tb/config, simulator spectre
  Models: /opt/pdk/ams/410/spectre/c35/processOption.scs, /opt/pdk/ams/410/spectre/c35/cmos53.scs[cmostm], /opt/pdk/ams/410/spectre/c35/res.scs[restm], /opt/pdk/ams/410/spectre/c35/cap.scs[captm], /opt/pdk/ams/410/spectre/c35/bip.scs[biptm], /opt/pdk/ams/410/spectre/c35/ind.scs[indtm], /opt/pdk/ams/410/spectre/c35/esddiode.scs[esddiodetm]
  Variables: CM_PULSE = 0; VDD_PULSE = 0; VIN_PULSE = 1m; F0 = 3.3; F1 = 3.3; F2 = 0; S0 = 1; S1 = 0; S2 = 0; VCM_AMP = 0; VIN_FREQ = 50; VIN_AMP = 0.8m; FC = 4k; VCM_AC = 0; VCM_DC = 1.5; VDD = 3.3; VIN_AC = 1; VIN_DC = 0
  Temperature: 27
  Simulator options: reltol=100e-6 homotopy=all limit=delta additionalArgs=enable_pre_ver=yes ignorezerovar=yes
  Files: definitions /opt/pdk/ams/410/spectre/c35/soac/soac.scs
  Analysis pss: engine=Shooting fund=50 harms=10 errpreset=conservative
  Analysis tran: stop=100m errpreset=conservative
  Analysis dc: (saves the operating point)
  Signals: /VOUT, /VCM, /VDDA
Test TRAN_VIN_PULSE: YAOWEN/fecg_front_end_tran_tb/config, simulator spectre
  Models: /opt/pdk/ams/410/spectre/c35/processOption.scs, /opt/pdk/ams/410/spectre/c35/cmos53.scs[cmostm], /opt/pdk/ams/410/spectre/c35/res.scs[restm], /opt/pdk/ams/410/spectre/c35/cap.scs[captm], /opt/pdk/ams/410/spectre/c35/bip.scs[biptm], /opt/pdk/ams/410/spectre/c35/ind.scs[indtm], /opt/pdk/ams/410/spectre/c35/esddiode.scs[esddiodetm]
  Variables: CM_PULSE = 0; VDD_PULSE = 0; VIN_PULSE = 1m; F0 = 3.3; F1 = 3.3; F2 = 0; S0 = 1; S1 = 0; S2 = 0; VCM_AMP = 0; VIN_FREQ = 50; VIN_AMP = 0; FC = 1k; VCM_AC = 0; VCM_DC = 1.5; VDD = 3.3; VIN_AC = 1; VIN_DC = 0
  Temperature: 27
  Simulator options: reltol=100e-6 homotopy=all limit=delta additionalArgs=enable_pre_ver=yes ignorezerovar=yes
  Files: definitions /opt/pdk/ams/410/spectre/c35/soac/soac.scs
  Analysis tran: stop=2000m errpreset=conservative
  Analysis dc: (saves the operating point)
  Signals: /VOUT, /VCM, /VDDA, /I19/VIA, /I19/VLF1, /I19/VGA, /I19/VLF2
Test TRAN_VDD_PULSE: YAOWEN/fecg_front_end_tran_tb/config, simulator spectre
  Models: /opt/pdk/ams/410/spectre/c35/processOption.scs, /opt/pdk/ams/410/spectre/c35/cmos53.scs[cmostm], /opt/pdk/ams/410/spectre/c35/res.scs[restm], /opt/pdk/ams/410/spectre/c35/cap.scs[captm], /opt/pdk/ams/410/spectre/c35/bip.scs[biptm], /opt/pdk/ams/410/spectre/c35/ind.scs[indtm], /opt/pdk/ams/410/spectre/c35/esddiode.scs[esddiodetm]
  Variables: CM_PULSE = 0; VDD_PULSE = 3.3; VIN_PULSE = 0; F0 = 3.3; F1 = 3.3; F2 = 0; S0 = 1; S1 = 0; S2 = 0; VCM_AMP = 0; VIN_FREQ = 50; VIN_AMP = 0; FC = 4k; VCM_AC = 0; VCM_DC = 1.5; VDD = 0; VIN_AC = 1; VIN_DC = 0
  Temperature: 27
  Simulator options: reltol=100e-6 homotopy=all limit=delta additionalArgs=enable_pre_ver=yes ignorezerovar=yes
  Files: definitions /opt/pdk/ams/410/spectre/c35/soac/soac.scs
  Analysis tran: stop=1.5 errpreset=conservative
  Analysis dc: (saves the operating point)
  Signals: /VOUT, /VCM, /VDDA, /I19/VIA, /I19/VLF1, /I19/VGA, /I19/VLF2
Test TRAN_VDD_PULSE_MC: YAOWEN/fecg_front_end_tran_tb/config, simulator spectre
  Models: /opt/pdk/ams/410/spectre/c35/processOption.scs, /opt/pdk/ams/410/spectre/c35/cmos53.scs[cmosmc], /opt/pdk/ams/410/spectre/c35/res.scs[resmc], /opt/pdk/ams/410/spectre/c35/cap.scs[capmc], /opt/pdk/ams/410/spectre/c35/bip.scs[bipmc], /opt/pdk/ams/410/spectre/c35/ind.scs[indmc], /opt/pdk/ams/410/spectre/c35/esddiode.scs[esddiodemc]
  Variables: CM_PULSE = 0; VDD_PULSE = 3.3; VIN_PULSE = 0; F0 = 3.3; F1 = 3.3; F2 = 0; S0 = 1; S1 = 0; S2 = 0; VCM_AMP = 0; VIN_FREQ = 50; VIN_AMP = 0; FC = 4k; VCM_AC = 0; VCM_DC = 1.5; VDD = 0; VIN_AC = 1; VIN_DC = 0
  Temperature: 27
  Simulator options: reltol=100e-6 homotopy=all limit=delta additionalArgs=enable_pre_ver=yes ignorezerovar=yes
  Files: definitions /opt/pdk/ams/410/spectre/c35/soac/soac.scs
  Analysis tran: stop=1.5 errpreset=conservative
  Signals: /VOUT, /VCM, /VDDA, /I19/VIA, /I19/VLF1, /I19/VGA, /I19/VLF2
