ADE simulation setup
Run mode: Single Run, Sweeps and Corners
Tests:
  TRAN_VIN (off): YAOWEN/fecg_front_end_tran_tb/config, simulator spectre
    Variables: VIN_FREQ = 50; VIN_AMP = 0; FC = 4k; VCM_AC = 0; VCM_DC = 1.5; VDD = 3.3; VIN_AC = 1; VIN_DC = 0; F0 = 3.3; F1 = 3.3; F2 = 0; S0 = 1; S1 = 0; S2 = 0; VCM_AMP = 0; CM_PULSE = 0; VDD_PULSE = 0; VIN_PULSE = 0
    Outputs: /VOUT; /VCM; /VDDA
  TRAN_VIN_PULSE (off): YAOWEN/fecg_front_end_tran_tb/config, simulator spectre
    Variables: VIN_FREQ = 50; VIN_AMP = 0; FC = 1k; VCM_AC = 0; VCM_DC = 1.5; VDD = 3.3; VIN_AC = 1; VIN_DC = 0; F0 = 3.3; F1 = 3.3; F2 = 0; S0 = 1; S1 = 0; S2 = 0; VCM_AMP = 0; CM_PULSE = 0; VDD_PULSE = 0; VIN_PULSE = -1m
    Outputs: /VOUT; /VCM; /VDDA; /I19/VIA; /I19/VLF1; /I19/VGA; /I19/VLF2
  TRAN_VDD_PULSE: YAOWEN/fecg_front_end_tran_tb/config, simulator spectre
    Variables: VIN_FREQ = 50; VIN_AMP = 0; FC = 4k; VCM_AC = 0; VCM_DC = 1.5; VDD = 0; VIN_AC = 1; VIN_DC = 0; F0 = 3.3; F1 = 3.3; F2 = 0; S0 = 1; S1 = 0; S2 = 0; VCM_AMP = 0; CM_PULSE = 0; VDD_PULSE = 3.3; VIN_PULSE = 0
    Outputs: /VOUT; /VCM; /VDDA; /I19/VIA; /I19/VLF1; /I19/VGA; /I19/VLF2
  TRAN_VDD_PULSE_MC (off): YAOWEN/fecg_front_end_tran_tb/config, simulator spectre
    Variables: VIN_FREQ = 50; VIN_AMP = 0; FC = 4k; VCM_AC = 0; VCM_DC = 1.5; VDD = 0; VIN_AC = 1; VIN_DC = 0; F0 = 3.3; F1 = 3.3; F2 = 0; S0 = 1; S1 = 0; S2 = 0; VCM_AMP = 0; CM_PULSE = 0; VDD_PULSE = 3.3; VIN_PULSE = 0
    Outputs: /VOUT; /VCM; /VDDA; /I19/VIA; /I19/VLF1; /I19/VGA; /I19/VLF2
Global variables:
  FC = 4k (off)
  F0 = 3.3
  F1 = 3.3
  F2 = 0
  S0 = 3.3
  S1 = 3.3
  S2 = 0
  S3 = 0
Corners (all switched off):
  model folders: /opt/pdk/ams/410/spectre/c35
  every corner: /opt/pdk/ams/410/spectre/c35/processOption.scs, /opt/pdk/ams/410/spectre/c35/cmos53.scs[cmoswo cmoswp cmosws cmoswz], /opt/pdk/ams/410/spectre/c35/bip.scs[biptm], /opt/pdk/ams/410/spectre/c35/ind.scs[indtm], /opt/pdk/ams/410/spectre/c35/esddiode.scs[esddiodetm]
  CMOS (off): res.scs[restm], cap.scs[captm]
  CMOS_VDD (off): res.scs[restm], cap.scs[captm]
  CMOS_VDD_TEMP (off): temperature=-40 85; res.scs[restm], cap.scs[captm]
  CMOS_RES_CAP_VDD_TEMP (off): temperature=-40 85; VDD=2.97 3.63; res.scs[reswp resws], cap.scs[capwp capws]
  CMOS_RES_CAP_TEMP: temperature=-40 85; res.scs[reswp resws], cap.scs[capwp capws]
