ADE simulation setup
Run mode: Monte Carlo Sampling
Tests:
  myproject:bgp_bias:1 (off): myproject/bgp_bias/schematic, simulator spectre
  montecarlo: myproject/bgp_bias/schematic, simulator spectre
Global variables:
  VDD = 3.3
Corners (all switched off):
  model folders: /opt/pdk/ams/410/spectre/c35/soac
  every corner: /opt/pdk/ams/410/spectre/c35/soac/processOption.scs, /opt/pdk/ams/410/spectre/c35/soac/ind.scs[indtm]
  Corner (off): temperature=-40 85; cmos53.scs[cmoswo cmoswp cmosws], res.scs[reswp resws], cap.scs[capwp capws], bip.scs[biphs biplb biphb], esddiode.scs[esddiodetm esddiodemc]
  CMOS (off): cmos53.scs[cmoswo cmoswp cmosws cmoswz], res.scs[restm], cap.scs[captm], bip.scs[biptm], esddiode.scs[esddiodetm]
  CMOSres (off): VDD=2.97  3.63; cmos53.scs[cmoswo cmoswp cmosws cmoswz], res.scs[reswp resws], cap.scs[captm], bip.scs[biptm], esddiode.scs[esddiodetm]
  CMOSresbip: temperature=-40 85; VDD=2.97  3.63; cmos53.scs[cmoswo cmoswp cmosws cmoswz], res.scs[reswp resws], cap.scs[captm], bip.scs[biphb biplb biphs], esddiode.scs[esddiodetm]
Monte Carlo Sampling options: mcmethod=all, mcnumpoints=1, parasiticanalysis=0, dutsubckts=/C0;/C1;/C2;/R0;/R2;/R3;, ignoremode=default
