ADE simulation setup
Test myproject_bgp_bias_1: myproject/bgp_bias/schematic, simulator spectre
  Models: /opt/pdk/ams/410/spectre/c35/processOption.scs, /opt/pdk/ams/410/spectre/c35/cmos53.scs[cmostm], /opt/pdk/ams/410/spectre/c35/res.scs[restm], /opt/pdk/ams/410/spectre/c35/cap.scs[captm], /opt/pdk/ams/410/spectre/c35/bip.scs[biptm], /opt/pdk/ams/410/spectre/c35/ind.scs[indtm], /opt/pdk/ams/410/spectre/c35/esddiode.scs[esddiodetm]
  Variables: VDD = 3.3
  Temperature: 27
  Simulator options: reltol=100e-6 homotopy=all limit=delta additionalArgs=enable_pre_ver=yes ignorezerovar=yes
  Files: definitions /opt/pdk/ams/410/spectre/c35/soac/soac.scs
  Analysis dc: sweep VDD start=0 stop=3.3 step=10m (saves the operating point)
  Signals: /vout
