ADE simulation setup
Run mode: Monte Carlo Sampling
Tests:
  myproject_bgp_bias_1 (off): myproject/bgp_bias_final/schematic, simulator spectre
    Variables: VDD = 3.3; vddstep = 0
    Outputs: /vout
  mc: myproject/bgp_bias_final/schematic, simulator spectre
    Variables: VDD = 3.3; vddstep = 0
    Outputs: /vout
  dcsweep (off): myproject/bgp_bias_final/schematic, simulator spectre
    Variables: VDD = 3.3; vddstep = 0
    Outputs: /vout
Corners (all switched off):
  model folders: /opt/pdk/ams/410/spectre/c35
  CMOSresbipcapvdd: temperature=-40 85; VDD=2.97 3.63; processOption.scs, cmos53.scs[cmoswo cmoswp cmosws cmoswz], res.scs[reswp resws], cap.scs[capwp capws], bip.scs[biphb biplb biphs], ind.scs[indtm], esddiode.scs[esddiodetm]
  CMOSresbipcap (off): temperature=-40 85; processOption.scs, cmos53.scs[cmoswo cmoswp cmosws cmoswz], res.scs[reswp resws], cap.scs[capwp capws], bip.scs[biphb biplb biphs], ind.scs[indtm], esddiode.scs[esddiodetm]
Monte Carlo Sampling options: mismatchvary=Gaussian, sssnumpoints=7000, mismatchscale=1, processscale=1, pointsPerJobPolicy=Group automatically, maxPointsPerJob=10, reliabilitymode=singlestress, wcdinitialpoints=200, mcnumpoints=500, yeyistostart=3.0, mcSigmaTarget=3, yeiterations=10, processvary=Gaussian, yeexpectedyield=3, mcmethod=all, yeusehistorymc=0, yeuseautomcsamples=1, yecreatecorners=0, mcdistandscalingmismatchenable=0, parasiticanalysis=0, mcFilterPluginEnabled=0, haveyeyieldtostart=1, yeusevarreduction=1, mcdistandscalingprocessenable=0
