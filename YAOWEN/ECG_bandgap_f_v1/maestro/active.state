ADE simulation setup
Test myproject_bgp_bias_1: myproject/bgp_bias_final/schematic, simulator spectre
  Models: /opt/pdk/ams/410/spectre/c35/processOption.scs, /opt/pdk/ams/410/spectre/c35/cmos53.scs[cmostm], /opt/pdk/ams/410/spectre/c35/res.scs[restm], /opt/pdk/ams/410/spectre/c35/cap.scs[captm], /opt/pdk/ams/410/spectre/c35/bip.scs[biptm], /opt/pdk/ams/410/spectre/c35/ind.scs[indtm], /opt/pdk/ams/410/spectre/c35/esddiode.scs[esddiodetm]
  Variables: vddstep = 0; VDD = 3.3
  Temperature: 27
  Simulator options: reltol=100e-6 homotopy=all limit=delta additionalArgs=enable_pre_ver=yes ignorezerovar=yes
  Files: definitions /opt/pdk/ams/410/spectre/c35/soac/soac.scs
  Analysis xf: start=0.01 stop=100M p=/vout
  Output V/V /V0; xf dB20(V/V) = db(getData("/V0" ?result "xf"))
  Signals: /vout
Test dcsweep: myproject/bgp_bias_final/schematic, simulator spectre
  Models: /opt/pdk/ams/410/spectre/c35/processOption.scs, /opt/pdk/ams/410/spectre/c35/cmos53.scs[cmostm], /opt/pdk/ams/410/spectre/c35/res.scs[restm], /opt/pdk/ams/410/spectre/c35/cap.scs[captm], /opt/pdk/ams/410/spectre/c35/bip.scs[biptm], /opt/pdk/ams/410/spectre/c35/ind.scs[indtm], /opt/pdk/ams/410/spectre/c35/esddiode.scs[esddiodetm]
  Variables: vddstep = 0; VDD = 3.3
  Temperature: 27
  Simulator options: reltol=100e-6 homotopy=all limit=delta additionalArgs=enable_pre_ver=yes ignorezerovar=yes
  Files: definitions /opt/pdk/ams/410/spectre/c35/soac/soac.scs
  Analysis dc: sweep VDD start=0 stop=3.3 step=10m (saves the operating point)
  Signals: /vout
Test mc: myproject/bgp_bias_final/schematic, simulator spectre
  Models: /opt/pdk/ams/410/spectre/c35/processOption.scs, /opt/pdk/ams/410/spectre/c35/cmos53.scs[cmosmc], /opt/pdk/ams/410/spectre/c35/res.scs[resmc], /opt/pdk/ams/410/spectre/c35/cap.scs[capmc], /opt/pdk/ams/410/spectre/c35/bip.scs[bipmc], /opt/pdk/ams/410/spectre/c35/ind.scs[indmc], /opt/pdk/ams/410/spectre/c35/esddiode.scs[esddiodemc]
  Variables: vddstep = 0; VDD = 3.3
  Temperature: 27
  Simulator options: reltol=100e-6 homotopy=all limit=delta additionalArgs=enable_pre_ver=yes ignorezerovar=yes
  Files: definitions /opt/pdk/ams/410/spectre/c35/soac/soac.scs
  Analysis xf: start=0.01 stop=100M p=/vout
  Output V/V /V0; xf dB20(V/V) = db(getData("/V0" ?result "xf"))
  Signals: /vout
Run mode: Monte Carlo Sampling
Corners (all switched off):
  model folders: /opt/pdk/ams/410/spectre/c35
  CMOSresbipcapvdd: temperature=-40 85; VDD=2.97 3.63; processOption.scs, cmos53.scs[cmoswo cmoswp cmosws cmoswz], res.scs[reswp resws], cap.scs[capwp capws], bip.scs[biphb biplb biphs], ind.scs[indtm], esddiode.scs[esddiodetm]
  CMOSresbipcap (off): temperature=-40 85; processOption.scs, cmos53.scs[cmoswo cmoswp cmosws cmoswz], res.scs[reswp resws], cap.scs[capwp capws], bip.scs[biphb biplb biphs], ind.scs[indtm], esddiode.scs[esddiodetm]
Monte Carlo Sampling options: mismatchvary=Gaussian, sssnumpoints=7000, mismatchscale=1, processscale=1, pointsPerJobPolicy=Group automatically, maxPointsPerJob=10, reliabilitymode=singlestress, wcdinitialpoints=200, mcnumpoints=500, yeyistostart=3.0, mcSigmaTarget=3, yeiterations=10, processvary=Gaussian, yeexpectedyield=3, mcmethod=all, yeusehistorymc=0, yeuseautomcsamples=1, yecreatecorners=0, mcdistandscalingmismatchenable=0, parasiticanalysis=0, mcFilterPluginEnabled=0, haveyeyieldtostart=1, yeusevarreduction=1, mcdistandscalingprocessenable=0
Disabled tests: dcsweep, myproject_bgp_bias_1
