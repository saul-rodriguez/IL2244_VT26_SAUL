ADE simulation setup
Run mode: Single Run, Sweeps and Corners
Tests:
  PSS_VIN: YAOWEN/fecg_front_end_tb/config, simulator spectre
    Variables: VIN_FREQ = 50; VIN_AMP = 1m; FC = 2K; VCM_AC = 0; VCM_DC = 1.6; VDD = 3.3; VIN_AC = 1; VIN_DC = 10m; F0 = 3.3; F1 = 3.3; F2 = 0; S0 = 1; S1 = 0; S2 = 0; VCM_AMP = 0; EN_CMFB = 3.3
    Outputs: VOUT_d2_dB; VIA_d2_dB; VLF1_d2_dB; VGA_d2_dB; VLF2_d2_dB1; VOUT_V; VOUT_V_DC; DC current consumption
  PSS_PXF_PNOISE (off): YAOWEN/fecg_front_end_tb/config, simulator spectre
    Variables: VIN_FREQ = 50; VIN_AMP = 0; FC = 2K; VCM_AC = 0; VCM_DC = 1.6; VDD = 3.3; VIN_AC = 1; VIN_DC = 10m; F0 = 3.3; F1 = 3.3; F2 = 0; S0 = 1; S1 = 0; S2 = 0; VCM_AMP = 0; EN_CMFB = 3.3
    Outputs: Output_Noise_Vrms; CM_Gain_dB; Diff_Gain_dB; CM_Gain_50Hz; CM_Gain_50Hz_dB; Diff_Gain_50Hz; Diff_Gain_50Hz_dB; CMRR_50Hz_dB; Input_ref_noise_Vrms; Output_noise_Vrms; VOUT_V_DC
  PSS_VIN_MC (off): FECG/fecg_front_end_tb/config, simulator spectre
    Variables: VIN_FREQ = 50; VIN_AMP = 1m; FC = 2K; VCM_AC = 0; VCM_DC = 1.6; VDD = 3.3; VIN_AC = 1; VIN_DC = 10m; F0 = 3.3; F1 = 3.3; F2 = 0; S0 = 1; S1 = 0; S2 = 0; VCM_AMP = 0; EN_CMFB = 3.3
    Outputs: VOUT_d2_dB; VIA_d2_dB; VLF1_d2_dB; VGA_d2_dB; VLF2_d2_dB1; VOUT_V; VOUT_V_DC
  PSS_PXF_PNOISE_MC (off): FECG/fecg_front_end_tb/config, simulator spectre
    Variables: VIN_FREQ = 50; VIN_AMP = 0; FC = 4k; VCM_AC = 0; VCM_DC = 1.6; VDD = 3.3; VIN_AC = 1; VIN_DC = 10m; F0 = 3.3; F1 = 3.3; F2 = 0; S0 = 1; S1 = 0; S2 = 0; VCM_AMP = 0; EN_CMFB = 3.3
    Outputs: Output_Noise_Vrms; CM_Gain_dB; Diff_Gain_dB; CM_Gain_50Hz; CM_Gain_50Hz_dB; Diff_Gain_50Hz; Diff_Gain_50Hz_dB; CMRR_50Hz_dB; Input_ref_noise_Vrms; Output_noise_Vrms; VOUT_V_DC
Global variables:
  FC = 4k
  F0 = 3.3
  F1 = 3.3
  F2 = 0
  S0 = 3.3
  S1 = 3.3
  S2 = 0
  EN_CMFB = 0
  S3 = 0
Corners (all switched off):
  model folders: /opt/pdk/ams/410/spectre/c35
  every corner: /opt/pdk/ams/410/spectre/c35/processOption.scs, /opt/pdk/ams/410/spectre/c35/cmos53.scs[cmoswo cmoswp cmosws cmoswz], /opt/pdk/ams/410/spectre/c35/bip.scs[biptm], /opt/pdk/ams/410/spectre/c35/ind.scs[indtm], /opt/pdk/ams/410/spectre/c35/esddiode.scs[esddiodetm]
  CMOS (off): res.scs[restm], cap.scs[captm]
  CMOS_VDD (off): res.scs[restm], cap.scs[captm]
  CMOS_VDD_TEMP (off): temperature=-40 85; res.scs[restm], cap.scs[captm]
  CMOS_RES_CAP_VDD_TEMP: temperature=-40 85; VDD=2.97 3.63; res.scs[reswp resws], cap.scs[capwp capws]
  CMOS_RES_CAP_TEMP (off): temperature=-40 85; res.scs[reswp resws], cap.scs[capwp capws]
Specs:
  PSS_VIN / VOUT_V: > 1
  PSS_VIN / VOUT_d2_dB: > 60
  PSS_VIN_MC / VOUT_V: > 1
  PSS_VIN_MC / VOUT_d2_dB: > 60
  PSS_VIN / VOUT_V_DC: > 1
  PSS_VIN_MC / VOUT_V_DC: > 1
  PSS_PXF_PNOISE_MC / VOUT_V_DC: > 1
  PSS_PXF_PNOISE / VOUT_V_DC: > 1
