ADE simulation setup
Test PSS_PXF_PNOISE: FECG/fecg_front_end_tb/config, simulator spectre
  Models: /opt/pdk/ams/410/spectre/c35/processOption.scs, /opt/pdk/ams/410/spectre/c35/cmos53.scs[cmostm], /opt/pdk/ams/410/spectre/c35/res.scs[restm], /opt/pdk/ams/410/spectre/c35/cap.scs[captm], /opt/pdk/ams/410/spectre/c35/bip.scs[biptm], /opt/pdk/ams/410/spectre/c35/ind.scs[indtm], /opt/pdk/ams/410/spectre/c35/esddiode.scs[esddiodetm]
  Variables: EN_CMFB = 3.3; F0 = 3.3; F1 = 3.3; F2 = 0; S0 = 1; S1 = 0; S2 = 0; VCM_AMP = 0; VIN_FREQ = 50; VIN_AMP = 0; FC = 2K; VCM_AC = 0; VCM_DC = 1.6; VDD = 3.3; VIN_AC = 1; VIN_DC = 10m
  Temperature: 27
  Simulator options: reltol=100e-6 homotopy=all limit=delta additionalArgs=enable_pre_ver=yes ignorezerovar=yes
  Files: definitions /opt/pdk/ams/410/spectre/c35/soac/soac.scs
  Analysis pxf: start=0.01 stop=100k fund=4K p=/VOUT sweeptype=relative relharmnum=0 sidebands=("0")
  Analysis dc: (saves the operating point)
  Analysis pss: engine=Shooting fund=4K harms=40 errpreset=conservative
  Analysis pnoise: start=0.01 stop=100k dec=20 fund=4K p=/VOUT sweeptype=relative relharmnum=0 maxsideband=10 noisetype=timeaverage
  Output Output_Noise_Vrms = sqrt(totalNoise("pnoise" 0.01 100000 nil))
  Output CM_Gain_dB = db(getData("/V2" ?result "pxf"))
  Output CM_Gain_50Hz = value(leafValue(mag(getData("/V2" ?result "pxf")) "harmonic" 0) 50)
  Output CM_Gain_50Hz_dB = value(leafValue(db(getData("/V2" ?result "pxf")) "harmonic" 0) 50)
  Output Diff_Gain_dB = db(getData("/V7" ?result "pxf"))
  Output Diff_Gain_50Hz = value(leafValue(mag(getData("/V7" ?result "pxf")) "harmonic" 0) 50)
  Output Diff_Gain_50Hz_dB = value(leafValue(db(getData("/V7" ?result "pxf")) "harmonic" 0) 50)
  Output CMRR_50Hz_dB = (value(leafValue(db(getData("/V7" ?result "pxf")) "harmonic" 0) 50) - value(leafValue(db(getData("/V2" ?result "pxf")) "harmonic" 0) 50))
  Output Input_ref_noise_Vrms = (sqrt(totalNoise("pnoise" 0.01 100000 nil)) / value(leafValue(mag(getData("/V7" ?result "pxf")) "harmonic" 0) 50))
  Output Output_noise_Vrms = sqrt(totalNoise("pnoise" 0.01 100000 nil))
  Output VOUT_V_DC = harmonic(mag(vh('pss "/VOUT")) 0)
Test PSS_VIN_MC: FECG/fecg_front_end_tb/config, simulator spectre
  Models: /opt/pdk/ams/410/spectre/c35/processOption.scs, /opt/pdk/ams/410/spectre/c35/cmos53.scs[cmosmc], /opt/pdk/ams/410/spectre/c35/res.scs[resmc], /opt/pdk/ams/410/spectre/c35/cap.scs[capmc], /opt/pdk/ams/410/spectre/c35/bip.scs[bipmc], /opt/pdk/ams/410/spectre/c35/ind.scs[indmc], /opt/pdk/ams/410/spectre/c35/esddiode.scs[esddiodemc]
  Variables: EN_CMFB = 3.3; F0 = 3.3; F1 = 3.3; F2 = 0; S0 = 1; S1 = 0; S2 = 0; VCM_AMP = 0; VIN_FREQ = 50; VIN_AMP = 1m; FC = 2K; VCM_AC = 0; VCM_DC = 1.6; VDD = 3.3; VIN_AC = 1; VIN_DC = 10m
  Temperature: 27
  Simulator options: reltol=100e-6 homotopy=all limit=delta additionalArgs=enable_pre_ver=yes ignorezerovar=yes
  Files: definitions /opt/pdk/ams/410/spectre/c35/soac/soac.scs
  Analysis dc: (saves the operating point)
  Analysis pss: engine=Shooting fund=50 harms=10 errpreset=conservative
  Output v /I19/VIA; pss (V) = vtime('pss "/I19/VIA")
  Output v /I19/VLF1; pss (V) = vtime('pss "/I19/VLF1")
  Output v /I19/VGA; pss (V) = vtime('pss "/I19/VGA")
  Output v /I19/VLF2; pss (V) = vtime('pss "/I19/VLF2")
  Output v /VOUT; pss (V) = vtime('pss "/VOUT")
  Output v /VOUT; pss dB20(V) = db(vh('pss "/VOUT"))
  Output VIA_d2_dB = (harmonic(db(vh('pss "/I19/VIA")) 1) - harmonic(db(vh('pss "/I19/VIA")) 2))
  Output VLF1_d2_dB = (harmonic(db(vh('pss "/I19/VLF1")) 1) - harmonic(db(vh('pss "/I19/VLF1")) 2))
  Output VGA_d2_dB = (harmonic(db(vh('pss "/I19/VGA")) 1) - harmonic(db(vh('pss "/I19/VGA")) 2))
  Output VLF2_d2_dB1 = (harmonic(db(vh('pss "/I19/VLF2")) 1) - harmonic(db(vh('pss "/I19/VLF2")) 2))
  Output VOUT_d2_dB = (harmonic(db(vh('pss "/VOUT")) 1) - harmonic(db(vh('pss "/VOUT")) 2))
  Output VOUT_V = harmonic(mag(vh('pss "/VOUT")) 1)
  Output VOUT_V_DC = harmonic(mag(vh('pss "/VOUT")) 0)
Test PSS_PXF_PNOISE_MC: FECG/fecg_front_end_tb/config, simulator spectre
  Models: /opt/pdk/ams/410/spectre/c35/processOption.scs, /opt/pdk/ams/410/spectre/c35/cmos53.scs[cmosmc], /opt/pdk/ams/410/spectre/c35/res.scs[resmc], /opt/pdk/ams/410/spectre/c35/cap.scs[capmc], /opt/pdk/ams/410/spectre/c35/bip.scs[bipmc], /opt/pdk/ams/410/spectre/c35/ind.scs[indmc], /opt/pdk/ams/410/spectre/c35/esddiode.scs[esddiodemc]
  Variables: EN_CMFB = 3.3; F0 = 3.3; F1 = 3.3; F2 = 0; S0 = 1; S1 = 0; S2 = 0; VCM_AMP = 0; VIN_FREQ = 50; VIN_AMP = 0; FC = 4k; VCM_AC = 0; VCM_DC = 1.6; VDD = 3.3; VIN_AC = 1; VIN_DC = 10m
  Temperature: 27
  Simulator options: reltol=100e-6 homotopy=all limit=delta additionalArgs=enable_pre_ver=yes ignorezerovar=yes
  Files: definitions /opt/pdk/ams/410/spectre/c35/soac/soac.scs
  Analysis pxf: start=0.01 stop=100k fund=4K p=/VOUT sweeptype=relative relharmnum=0 sidebands=("0")
  Analysis dc: (saves the operating point)
  Analysis pss: engine=Shooting fund=4K harms=40 errpreset=conservative
  Analysis pnoise: start=0.01 stop=100k dec=20 fund=4K p=/VOUT sweeptype=relative relharmnum=0 maxsideband=10 noisetype=timeaverage
  Output Output_Noise_Vrms = sqrt(totalNoise("pnoise" 0.01 100000 nil))
  Output CM_Gain_dB = db(getData("/V2" ?result "pxf"))
  Output CM_Gain_50Hz = value(leafValue(mag(getData("/V2" ?result "pxf")) "harmonic" 0) 50)
  Output CM_Gain_50Hz_dB = value(leafValue(db(getData("/V2" ?result "pxf")) "harmonic" 0) 50)
  Output Diff_Gain_dB = db(getData("/V7" ?result "pxf"))
  Output Diff_Gain_50Hz = value(leafValue(mag(getData("/V7" ?result "pxf")) "harmonic" 0) 50)
  Output Diff_Gain_50Hz_dB = value(leafValue(db(getData("/V7" ?result "pxf")) "harmonic" 0) 50)
  Output CMRR_50Hz_dB = (value(leafValue(db(getData("/V7" ?result "pxf")) "harmonic" 0) 50) - value(leafValue(db(getData("/V2" ?result "pxf")) "harmonic" 0) 50))
  Output Input_ref_noise_Vrms = (sqrt(totalNoise("pnoise" 0.01 100000 nil)) / value(leafValue(mag(getData("/V7" ?result "pxf")) "harmonic" 0) 50))
  Output Output_noise_Vrms = sqrt(totalNoise("pnoise" 0.01 100000 nil))
  Output VOUT_V_DC = harmonic(mag(vh('pss "/VOUT")) 0)
Test PSS_VIN: YAOWEN/core_ecg_tb/config, simulator spectre
  Models: /opt/pdk/ams/410/spectre/c35/processOption.scs, /opt/pdk/ams/410/spectre/c35/cmos53.scs[cmostm], /opt/pdk/ams/410/spectre/c35/res.scs[restm], /opt/pdk/ams/410/spectre/c35/cap.scs[captm], /opt/pdk/ams/410/spectre/c35/bip.scs[biptm], /opt/pdk/ams/410/spectre/c35/ind.scs[indtm], /opt/pdk/ams/410/spectre/c35/esddiode.scs[esddiodetm]
  Variables: EN_CMFB = 3.3; F0 = 3.3; F1 = 3.3; F2 = 0; S0 = 1; S1 = 0; S2 = 0; VCM_AMP = 0; VIN_FREQ = 50; VIN_AMP = 1m; FC = 2K; VCM_AC = 0; VCM_DC = 1.6; VDD = 3.3; VIN_AC = 1; VIN_DC = 10m
  Temperature: 27
  Simulator options: reltol=100e-6 homotopy=all limit=delta additionalArgs=enable_pre_ver=yes ignorezerovar=yes
  Files: definitions /opt/pdk/ams/410/spectre/c35/soac/soac.scs
  Analysis dc: (saves the operating point)
  Analysis pss: engine=Shooting fund=50 harms=10 errpreset=conservative
  Output v /I19/VIA; pss (V) = vtime('pss "/I19/VIA")
  Output v /I19/VLF1; pss (V) = vtime('pss "/I19/VLF1")
  Output v /I19/VGA; pss (V) = vtime('pss "/I19/VGA")
  Output v /I19/VLF2; pss (V) = vtime('pss "/I19/VLF2")
  Output v /VOUT; pss (V) = vtime('pss "/VOUT")
  Output v /VOUT; pss dB20(V) = db(vh('pss "/VOUT"))
  Output VIA_d2_dB = (harmonic(db(vh('pss "/I19/VIA")) 1) - harmonic(db(vh('pss "/I19/VIA")) 2))
  Output VLF1_d2_dB = (harmonic(db(vh('pss "/I19/VLF1")) 1) - harmonic(db(vh('pss "/I19/VLF1")) 2))
  Output VGA_d2_dB = (harmonic(db(vh('pss "/I19/VGA")) 1) - harmonic(db(vh('pss "/I19/VGA")) 2))
  Output VLF2_d2_dB1 = (harmonic(db(vh('pss "/I19/VLF2")) 1) - harmonic(db(vh('pss "/I19/VLF2")) 2))
  Output VOUT_d2_dB = (harmonic(db(vh('pss "/VOUT")) 1) - harmonic(db(vh('pss "/VOUT")) 2))
  Output VOUT_V = harmonic(mag(vh('pss "/VOUT")) 1)
  Output VOUT_V_DC = harmonic(mag(vh('pss "/VOUT")) 0)
  Output DC current consumption = pv("V1" "i" ?result "dcOpInfo")
  Signals: /VOUT, /I19/VIA, /I19/VLF1, /I19/VGA, /I19/VLF2
Run mode: Single Run, Sweeps and Corners
Global variables:
  FC = 4k
  F0 = 3.3
  F1 = 3.3
  F2 = 0
  S0 = 3.3
  S1 = 3.3
  S2 = 0
  EN_CMFB = 0
  S3 = 0
Corners (all switched off):
  model folders: /opt/pdk/ams/410/spectre/c35
  every corner: /opt/pdk/ams/410/spectre/c35/processOption.scs, /opt/pdk/ams/410/spectre/c35/cmos53.scs[cmoswo cmoswp cmosws cmoswz], /opt/pdk/ams/410/spectre/c35/bip.scs[biptm], /opt/pdk/ams/410/spectre/c35/ind.scs[indtm], /opt/pdk/ams/410/spectre/c35/esddiode.scs[esddiodetm]
  CMOS (off): res.scs[restm], cap.scs[captm]
  CMOS_VDD (off): res.scs[restm], cap.scs[captm]
  CMOS_VDD_TEMP (off): temperature=-40 85; res.scs[restm], cap.scs[captm]
  CMOS_RES_CAP_VDD_TEMP: temperature=-40 85; VDD=2.97 3.63; res.scs[reswp resws], cap.scs[capwp capws]
  CMOS_RES_CAP_TEMP (off): temperature=-40 85; res.scs[reswp resws], cap.scs[capwp capws]
Specs:
  PSS_VIN / VOUT_V: > 1
  PSS_VIN / VOUT_d2_dB: > 60
  PSS_VIN_MC / VOUT_V: > 1
  PSS_VIN_MC / VOUT_d2_dB: > 60
  PSS_VIN / VOUT_V_DC: > 1
  PSS_VIN_MC / VOUT_V_DC: > 1
  PSS_PXF_PNOISE_MC / VOUT_V_DC: > 1
  PSS_PXF_PNOISE / VOUT_V_DC: > 1
Disabled tests: PSS_PXF_PNOISE_1, PSS_PXF_PNOISE_MC, PSS_VIN, PSS_VIN_MC
