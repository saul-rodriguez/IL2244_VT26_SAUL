ADE simulation setup
Test DC: FBIAS/fbias_cur_ref_tb/schematic, simulator spectre
  Models: /opt/pdk/ams/410/spectre/c35/processOption.scs, /opt/pdk/ams/410/spectre/c35/cmos53.scs[cmostm], /opt/pdk/ams/410/spectre/c35/res.scs[restm], /opt/pdk/ams/410/spectre/c35/cap.scs[captm], /opt/pdk/ams/410/spectre/c35/bip.scs[biptm], /opt/pdk/ams/410/spectre/c35/ind.scs[indtm], /opt/pdk/ams/410/spectre/c35/esddiode.scs[esddiodetm]
  Variables: VDD_STEP = 20m; VGB_STEP = 0; VBG = 1.2; VDD = 3.3
  Temperature: 27
  Simulator options: reltol=100e-6 homotopy=all limit=delta additionalArgs=enable_pre_ver=yes ignorezerovar=yes
  Files: definitions /opt/pdk/ams/410/spectre/c35/soac/soac.scs
  Analysis dc: (saves the operating point)
  Analysis tran: stop=100u errpreset=conservative
  Analysis noise: start=0.01 stop=100M dec=20 oprobe=/IPRB0
  Output DC_Out_current = IDC("/R1/PLUS")
  Output i /R1/PLUS; tran (I) = itime('tran "/R1/PLUS")
  Signals: /R1/PLUS (terminal) as Current_out, /VRES
Test DC_MC: FBIAS/fbias_cur_ref_tb/schematic, simulator spectre
  Models: /opt/pdk/ams/410/spectre/c35/processOption.scs, /opt/pdk/ams/410/spectre/c35/cmos53.scs[cmosmc], /opt/pdk/ams/410/spectre/c35/res.scs[resmc], /opt/pdk/ams/410/spectre/c35/cap.scs[capmc], /opt/pdk/ams/410/spectre/c35/bip.scs[bipmc], /opt/pdk/ams/410/spectre/c35/ind.scs[indtm], /opt/pdk/ams/410/spectre/c35/esddiode.scs[esddiodemc]
  Variables: VDD_STEP = 0; VGB_STEP = 20m; VBG = 1.2; VDD = 3.3
  Temperature: 27
  Simulator options: reltol=100e-6 homotopy=all limit=delta additionalArgs=enable_pre_ver=yes ignorezerovar=yes
  Files: definitions /opt/pdk/ams/410/spectre/c35/soac/soac.scs
  Analysis dc: (saves the operating point)
  Analysis tran: stop=100u errpreset=conservative
  Output DC_Out_current = IDC("/R1/PLUS")
  Output i /R1/PLUS; tran (I) = itime('tran "/R1/PLUS")
  Signals: /R1/PLUS (terminal) as Current_out, /VRES
