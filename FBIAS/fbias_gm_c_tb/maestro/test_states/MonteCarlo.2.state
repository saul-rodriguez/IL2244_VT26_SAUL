ADE simulation setup
Test DC: FBIAS/fbias_gm_c_tb/schematic, simulator spectre
  Models: /opt/pdk/ams/410/spectre/c35/soac/processOption.scs, /opt/pdk/ams/410/spectre/c35/soac/cmos53.scs[cmostm], /opt/pdk/ams/410/spectre/c35/soac/res.scs[restm], /opt/pdk/ams/410/spectre/c35/soac/cap.scs[captm], /opt/pdk/ams/410/spectre/c35/soac/bip.scs[biptm], /opt/pdk/ams/410/spectre/c35/soac/ind.scs[indtm], /opt/pdk/ams/410/spectre/c35/soac/esddiode.scs[esddiodetm]
  Variables: VDD_TR = 1u; VDD = 3.3; VDD_STEP = 0
  Temperature: 27
  Simulator options: reltol=100e-6 homotopy=all limit=delta additionalArgs=enable_pre_ver=yes ignorezerovar=yes
  Files: definitions /opt/pdk/ams/410/spectre/c35/soac/soac.scs
  Analysis dc: sweep VDD start=0 stop=3.3 step=20m (saves the operating point)
  Analysis xf: start=0.01 stop=100M dec=20 p=/VOUT1
  Output IDC("/R0/PLUS")
  Output IS("/R0/PLUS")
  Output V/V /V0; xf dB20(V/V) = db(getData("/V0" ?result "xf"))
  Output output noise; A / sqrt(Hz) = getData("out" ?result "noise")
  Output VT("/IPRB0/PLUS")
  Signals: /R0/PLUS (terminal), /IPRB0/PLUS (terminal) as /IPRB0/PLUS_V, /VDD, /I0/VDDA (terminal)
Test DC_MC: FBIAS/fbias_gm_c_tb/schematic, simulator spectre
  Models: /opt/pdk/ams/410/spectre/c35/soac/processOption.scs, /opt/pdk/ams/410/spectre/c35/soac/cmos53.scs[cmosmc], /opt/pdk/ams/410/spectre/c35/soac/res.scs[resmc], /opt/pdk/ams/410/spectre/c35/soac/cap.scs[capmc], /opt/pdk/ams/410/spectre/c35/soac/bip.scs[bipmc], /opt/pdk/ams/410/spectre/c35/soac/ind.scs[indmc], /opt/pdk/ams/410/spectre/c35/soac/esddiode.scs[esddiodemc]
  Variables: VDD_TR = 1u; VDD = 3.3; VDD_STEP = 0
  Temperature: 27
  Simulator options: reltol=100e-6 homotopy=all limit=delta additionalArgs=enable_pre_ver=yes ignorezerovar=yes
  Files: definitions /opt/pdk/ams/410/spectre/c35/soac/soac.scs
  Analysis dc: sweep VDD start=0 stop=3.3 step=20m (saves the operating point)
  Analysis xf: start=0.01 stop=100M dec=20 p=/VOUT1
  Output IDC("/R0/PLUS")
  Output IS("/R0/PLUS")
  Output V/V /V0; xf dB20(V/V) = db(getData("/V0" ?result "xf"))
  Output output noise; A / sqrt(Hz) = getData("out" ?result "noise")
  Output VT("/IPRB0/PLUS")
  Output copy = VT("/VDD")
  Signals: /R0/PLUS (terminal), /IPRB0/PLUS (terminal) as /IPRB0/PLUS_V, /VDD
Test TRAN: FBIAS/fbias_gm_c_tb/schematic, simulator spectre
  Models: /opt/pdk/ams/410/spectre/c35/soac/processOption.scs, /opt/pdk/ams/410/spectre/c35/soac/cmos53.scs[cmostm], /opt/pdk/ams/410/spectre/c35/soac/res.scs[restm], /opt/pdk/ams/410/spectre/c35/soac/cap.scs[captm], /opt/pdk/ams/410/spectre/c35/soac/bip.scs[biptm], /opt/pdk/ams/410/spectre/c35/soac/ind.scs[indtm], /opt/pdk/ams/410/spectre/c35/soac/esddiode.scs[esddiodetm]
  Variables: VDD_TR = 1u; VDD = 0; VDD_STEP = 3.3
  Temperature: 27
  Simulator options: reltol=100e-6 homotopy=all limit=delta additionalArgs=enable_pre_ver=yes ignorezerovar=yes
  Files: definitions /opt/pdk/ams/410/spectre/c35/soac/soac.scs
  Analysis tran: stop=500m errpreset=conservative
  Output IDC("/R0/PLUS")
  Output IS("/R0/PLUS")
  Output VT("/IPRB0/PLUS")
  Signals: /R0/PLUS (terminal), /IPRB0/PLUS (terminal) as /IPRB0/PLUS_V, /VDD, /I0/VDDA (terminal)
Test TRAN_MC: FBIAS/fbias_gm_c_tb/schematic, simulator spectre
  Models: /opt/pdk/ams/410/spectre/c35/soac/processOption.scs, /opt/pdk/ams/410/spectre/c35/soac/cmos53.scs[cmosmc], /opt/pdk/ams/410/spectre/c35/soac/res.scs[resmc], /opt/pdk/ams/410/spectre/c35/soac/cap.scs[capmc], /opt/pdk/ams/410/spectre/c35/soac/bip.scs[bipmc], /opt/pdk/ams/410/spectre/c35/soac/ind.scs[indmc], /opt/pdk/ams/410/spectre/c35/soac/esddiode.scs[esddiodemc]
  Variables: VDD_TR = 1u; VDD = 0; VDD_STEP = 3.3
  Temperature: 27
  Simulator options: reltol=100e-6 homotopy=all limit=delta additionalArgs=enable_pre_ver=yes ignorezerovar=yes
  Files: definitions /opt/pdk/ams/410/spectre/c35/soac/soac.scs
  Analysis tran: stop=500m errpreset=conservative
  Output IDC("/R0/PLUS")
  Output IS("/R0/PLUS")
  Output V/V /V0; xf dB20(V/V) = db(getData("/V0" ?result "xf"))
  Output output noise; A / sqrt(Hz) = getData("out" ?result "noise")
  Output VT("/IPRB0/PLUS")
  Output copy = VT("/VDD")
  Signals: /R0/PLUS (terminal), /IPRB0/PLUS (terminal) as /IPRB0/PLUS_V, /VDD
