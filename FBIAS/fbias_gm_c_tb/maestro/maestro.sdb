ADE simulation setup
Run mode: Monte Carlo Sampling
Tests:
  DC (off): FBIAS/fbias_gm_c_tb/schematic, simulator spectre
    Variables: VDD = 3.3; VDD_STEP = 0; VDD_TR = 1u
    Outputs: IDC("/R0/PLUS"); IS("/R0/PLUS"); VT("/IPRB0/PLUS"); /VDD; /I0/VDDA
  DC_MC (off): FBIAS/fbias_gm_c_tb/schematic, simulator spectre
    Variables: VDD = 3.3; VDD_STEP = 0; VDD_TR = 1u
    Outputs: IDC("/R0/PLUS"); IS("/R0/PLUS"); VT("/IPRB0/PLUS"); copy
  TRAN (off): FBIAS/fbias_gm_c_tb/schematic, simulator spectre
    Variables: VDD = 0; VDD_STEP = 3.3; VDD_TR = 1u
    Outputs: IDC("/R0/PLUS"); IS("/R0/PLUS"); VT("/IPRB0/PLUS"); /VDD; /I0/VDDA
  TRAN_MC: FBIAS/fbias_gm_c_tb/schematic, simulator spectre
    Variables: VDD = 0; VDD_STEP = 3.3; VDD_TR = 1m
    Outputs: VT("/IPRB0/PLUS"); copy
Corners (all switched off):
  model folders: /opt/pdk/ams/410/spectre/c35
  every corner: /opt/pdk/ams/410/spectre/c35/processOption.scs, /opt/pdk/ams/410/spectre/c35/cmos53.scs[cmoswo cmoswp cmosws cmoswz], /opt/pdk/ams/410/spectre/c35/bip.scs[biptm], /opt/pdk/ams/410/spectre/c35/ind.scs[indtm], /opt/pdk/ams/410/spectre/c35/esddiode.scs[esddiodetm]
  CMOS (off): res.scs[restm], cap.scs[captm]
  CMOS_VDD (off): VDD=2.97 3.63; res.scs[restm], cap.scs[captm]
  CMOS_RES_VDD (off): VDD=2.97 3.63; res.scs[reswp resws], cap.scs[captm]
  CMOS_VDD_TEMP (off): temperature=-40 85; VDD=2.97 3.63; res.scs[restm], cap.scs[captm]
  CMOS_RES_CAP_VDD_TEMP (off): temperature=-40 85; VDD=2.97 3.63; res.scs[reswp resws], cap.scs[capwp capws]
  CMOS_RES_CAP_TEMP: temperature=-40 85; res.scs[reswp resws], cap.scs[capwp capws]
Monte Carlo Sampling options: mismatchvary=Gaussian, sssnumpoints=7000, mismatchscale=1, processscale=1, pointsPerJobPolicy=Group automatically, maxPointsPerJob=10, reliabilitymode=singlestress, wcdinitialpoints=200, mcnumpoints=200, yeyistostart=3.0, mcSigmaTarget=3, yeiterations=10, processvary=Gaussian, yeexpectedyield=3, mcmethod=all, yeusehistorymc=0, yeuseautomcsamples=1, yecreatecorners=0, mcdistandscalingmismatchenable=0, parasiticanalysis=0, mcFilterPluginEnabled=0, haveyeyieldtostart=1, yeusevarreduction=1, mcdistandscalingprocessenable=0
