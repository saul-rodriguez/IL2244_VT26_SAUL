ADE simulation setup
Run mode: Single Run, Sweeps and Corners
Tests:
  DC: FBIAS/fbias_gm_c_tb/config, simulator spectre
    Variables: VDD = 3.3; VDD_STEP = 0; VDD_TR = 1u
    Outputs: IDC("/R0/PLUS"); IS("/R0/PLUS"); VT("/IPRB0/PLUS"); /VDD; /I0/VDDA
  DC_MC (off): FBIAS/fbias_gm_c_tb/config, simulator spectre
    Variables: VDD = 3.3; VDD_STEP = 0; VDD_TR = 1u
    Outputs: IDC("/R0/PLUS"); IS("/R0/PLUS"); VT("/IPRB0/PLUS"); copy
  TRAN (off): FBIAS/fbias_gm_c_tb/config, simulator spectre
    Variables: VDD = 0; VDD_STEP = 3.3; VDD_TR = 1u
    Outputs: IDC("/R0/PLUS"); IS("/R0/PLUS"); VT("/IPRB0/PLUS"); /VDD; /I0/VDDA
  TRAN_MC (off): FBIAS/fbias_gm_c_tb/config, simulator spectre
    Variables: VDD = 0; VDD_STEP = 3.3; VDD_TR = 1m
    Outputs: VT("/IPRB0/PLUS"); copy
Corners:
  model folders: /opt/pdk/ams/410/spectre/c35
  every corner: /opt/pdk/ams/410/spectre/c35/processOption.scs, /opt/pdk/ams/410/spectre/c35/cmos53.scs[cmoswo cmoswp cmosws cmoswz], /opt/pdk/ams/410/spectre/c35/bip.scs[biptm], /opt/pdk/ams/410/spectre/c35/ind.scs[indtm], /opt/pdk/ams/410/spectre/c35/esddiode.scs[esddiodetm]
  CMOS (off): res.scs[restm], cap.scs[captm]
  CMOS_VDD (off): VDD=2.97 3.63; res.scs[restm], cap.scs[captm]
  CMOS_RES_VDD (off): VDD=2.97 3.63; res.scs[reswp resws], cap.scs[captm]
  CMOS_VDD_TEMP (off): temperature=-40 85; VDD=2.97 3.63; res.scs[restm], cap.scs[captm]
  CMOS_RES_CAP_VDD_TEMP (off): temperature=-40 85; VDD=2.97 3.63; res.scs[reswp resws], cap.scs[capwp capws]
  CMOS_RES_CAP_TEMP: temperature=-40 85; res.scs[reswp resws], cap.scs[capwp capws]
