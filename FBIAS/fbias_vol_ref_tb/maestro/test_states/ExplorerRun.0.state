ADE simulation setup
Test DC: FBIAS/fbias_vol_ref_tb/schematic, simulator spectre
  Models: /opt/pdk/ams/410/spectre/c35/processOption.scs, /opt/pdk/ams/410/spectre/c35/cmos53.scs[cmostm], /opt/pdk/ams/410/spectre/c35/res.scs[restm], /opt/pdk/ams/410/spectre/c35/cap.scs[captm], /opt/pdk/ams/410/spectre/c35/bip.scs[biptm], /opt/pdk/ams/410/spectre/c35/ind.scs[indtm], /opt/pdk/ams/410/spectre/c35/esddiode.scs[esddiodetm]
  Variables: VDD_STEP = 0; VGB_STEP = 0; VBG = 1.2; VDD = 3.3
  Temperature: 27
  Simulator options: reltol=100e-6 homotopy=all limit=delta additionalArgs=enable_pre_ver=yes ignorezerovar=yes
  Files: definitions /opt/pdk/ams/410/spectre/c35/soac/soac.scs
  Analysis dc: (saves the operating point)
  Output VT("/V1600")
  Output V1600 = VDC("/V1600")
  Output V1500 = VDC("/V1500")
  Output V/V /V0; xf dB20(V/V) = db(getData("/V0" ?result "xf"))
  Signals: /V1600, /V1500
