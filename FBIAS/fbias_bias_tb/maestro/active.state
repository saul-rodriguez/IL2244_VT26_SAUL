ADE simulation setup
Test DC: FBIAS/fbias_bias_tb/schematic, simulator spectre
  Models: /opt/pdk/ams/410/spectre/c35/soac/processOption.scs, /opt/pdk/ams/410/spectre/c35/soac/cmos53.scs[cmostm], /opt/pdk/ams/410/spectre/c35/soac/res.scs[restm], /opt/pdk/ams/410/spectre/c35/soac/cap.scs[captm], /opt/pdk/ams/410/spectre/c35/soac/bip.scs[biptm], /opt/pdk/ams/410/spectre/c35/soac/ind.scs[indtm], /opt/pdk/ams/410/spectre/c35/soac/esddiode.scs[esddiodetm]
  Variables: VDD_PULSE = 0; VDD_TR = 1u; VDD = 3.3
  Temperature: 27
  Simulator options: reltol=100e-6 homotopy=all limit=delta additionalArgs=enable_pre_ver=yes ignorezerovar=yes
  Files: definitions /opt/pdk/ams/410/spectre/c35/soac/soac.scs
  Analysis dc: (saves the operating point)
  Analysis xf: start=0.01 stop=100M dec=20 p=/V1600
  Analysis noise: start=0.01 stop=100M dec=20 p=/V1600
  Output V/V /V0; xf dB20(V/V) = db(getData("/V0" ?result "xf"))
  Output V1600 = VDC("/V1600")
  Output Vnoise_rms_100MHz = sqrt(totalNoise("noise" 0.01 100000000 nil))
  Output Vnoise_rms_200Hz = sqrt(totalNoise("noise" 0.01 200 nil))
  Output PSRR_1Hz = value(db(getData("/V0" ?result "xf")) 1)
  Output IBIAS = IDC("/R1/PLUS")
  Signals: /V1600, /R1/PLUS (terminal)
Test DC_MC: FBIAS/fbias_bias_tb/schematic, simulator spectre
  Models: /opt/pdk/ams/410/spectre/c35/soac/processOption.scs, /opt/pdk/ams/410/spectre/c35/soac/cmos53.scs[cmosmc], /opt/pdk/ams/410/spectre/c35/soac/res.scs[resmc], /opt/pdk/ams/410/spectre/c35/soac/cap.scs[capmc], /opt/pdk/ams/410/spectre/c35/soac/bip.scs[bipmc], /opt/pdk/ams/410/spectre/c35/soac/ind.scs[indmc], /opt/pdk/ams/410/spectre/c35/soac/esddiode.scs[esddiodemc]
  Variables: VDD_PULSE = 0; VDD_TR = 1u; VDD = 3.3
  Temperature: 27
  Simulator options: reltol=100e-6 homotopy=all limit=delta additionalArgs=enable_pre_ver=yes ignorezerovar=yes
  Files: definitions /opt/pdk/ams/410/spectre/c35/soac/soac.scs
  Analysis dc: (saves the operating point)
  Analysis xf: start=0.01 stop=100M dec=20 p=/V1600
  Analysis noise: start=0.01 stop=100M dec=20 p=/V1600
  Output V/V /V0; xf dB20(V/V) = db(getData("/V0" ?result "xf"))
  Output V1600 = VDC("/V1600")
  Output Vnoise_rms_100MHz = sqrt(totalNoise("noise" 0.01 100000000 nil))
  Output Vnoise_rms_200Hz = sqrt(totalNoise("noise" 0.01 200 nil))
  Output PSRR_1Hz = value(db(getData("/V0" ?result "xf")) 1)
  Output IBIAS = IDC("/R1/PLUS")
  Signals: /V1600, /R1/PLUS (terminal)
Test TRAN: FBIAS/fbias_bias_tb/schematic, simulator spectre
  Models: /opt/pdk/ams/410/spectre/c35/soac/processOption.scs, /opt/pdk/ams/410/spectre/c35/soac/cmos53.scs[cmostm], /opt/pdk/ams/410/spectre/c35/soac/res.scs[restm], /opt/pdk/ams/410/spectre/c35/soac/cap.scs[captm], /opt/pdk/ams/410/spectre/c35/soac/bip.scs[biptm], /opt/pdk/ams/410/spectre/c35/soac/ind.scs[indtm], /opt/pdk/ams/410/spectre/c35/soac/esddiode.scs[esddiodetm]
  Variables: VDD_PULSE = 3.3; VDD_TR = 1u; VDD = 0
  Temperature: 27
  Simulator options: reltol=100e-6 homotopy=all limit=delta additionalArgs=enable_pre_ver=yes ignorezerovar=yes
  Files: definitions /opt/pdk/ams/410/spectre/c35/soac/soac.scs
  Analysis tran: stop=500m errpreset=conservative
  Signals: /V1600, /VDD, /POR_L, /R1/PLUS (terminal), /VRES, /I0/I2/BIAS (terminal) as Bias_BG, /I0/VBG as BG_V
Test TRAN_MC: FBIAS/fbias_bias_tb/schematic, simulator spectre
  Models: /opt/pdk/ams/410/spectre/c35/soac/processOption.scs, /opt/pdk/ams/410/spectre/c35/soac/cmos53.scs[cmosmc], /opt/pdk/ams/410/spectre/c35/soac/res.scs[resmc], /opt/pdk/ams/410/spectre/c35/soac/cap.scs[capmc], /opt/pdk/ams/410/spectre/c35/soac/bip.scs[bipmc], /opt/pdk/ams/410/spectre/c35/soac/ind.scs[indmc], /opt/pdk/ams/410/spectre/c35/soac/esddiode.scs[esddiodemc]
  Variables: VDD_PULSE = 3.3; VDD_TR = 1u; VDD = 0
  Temperature: 27
  Simulator options: reltol=100e-6 homotopy=all limit=delta additionalArgs=enable_pre_ver=yes ignorezerovar=yes
  Files: definitions /opt/pdk/ams/410/spectre/c35/soac/soac.scs
  Analysis tran: stop=500m errpreset=conservative
  Signals: /V1600, /VDD, /POR_L, /R1/PLUS (terminal), /VRES, /I0/I2/BIAS (terminal) as Bias_BG, /I0/VBG as BG_V
Run mode: Single Run, Sweeps and Corners
Corners:
  model folders: /opt/pdk/ams/410/spectre/c35
  every corner: /opt/pdk/ams/410/spectre/c35/processOption.scs, /opt/pdk/ams/410/spectre/c35/cmos53.scs[cmoswo cmoswp cmosws cmoswz], /opt/pdk/ams/410/spectre/c35/ind.scs[indtm], /opt/pdk/ams/410/spectre/c35/esddiode.scs[esddiodetm]
  CMOS (off): res.scs[restm], cap.scs[captm], bip.scs[biptm]
  CMOS_VDD (off): VDD=2.97 3.63; res.scs[restm], cap.scs[captm], bip.scs[biptm]
  CMOS_VDD_TEMP (off): temperature=-40 85; VDD=2.97 3.63; res.scs[restm], cap.scs[captm], bip.scs[biptm]
  CMOS_RES_CAP_VDD_TEMP (off): temperature=-40 85; VDD=2.97 3.63; res.scs[reswp resws], cap.scs[capwp capws], bip.scs[biptm]
  CMOS_RES_CAP_TEMP (off): temperature=-40 85; res.scs[reswp resws], cap.scs[capwp capws], bip.scs[biptm]
  CMOS_RES_BIP_VDD_TEMP (off): temperature=-40 85; VDD=2.97 3.63; res.scs[reswp resws], cap.scs[captm], bip.scs[biphb biphs biplb]
  CMOS_RES_BIP_TEMP (off): temperature=-40 85; res.scs[reswp resws], cap.scs[captm], bip.scs[biphb biphs biplb]
  CMOS_RES_CAP_BIP_TEMP: temperature=-40 85; res.scs[reswp resws], cap.scs[capwp capws], bip.scs[biphb biphs biplb]
  CMOS_RES_CAP_BIP_VDD_TEMP (off): temperature=-40 85; VDD=2.97 3.63; res.scs[reswp resws], cap.scs[capwp capws], bip.scs[biphb biphs biplb]
Setup values for test TRAN: VDD_TR = 1m
Setup values for test TRAN_MC: VDD_TR = 1m
Disabled tests: DC, DC_1, DC_MC, TRAN_MC
