ADE simulation setup
Run mode: Single Run, Sweeps and Corners
Tests:
  DC: FBIAS/fecg_bandgap_tb/schematic, simulator spectre
    Variables: VDD = 3.3; VDD_PULSE = 0; VDD_RISE = 1u
    Outputs: VDC("/BG_REF"); Output_noise_Vrms; Output_noise_ECG_Vrms
  DC_MC (off): FBIAS/fecg_bandgap_tb/schematic, simulator spectre
    Variables: VDD = 3.3; VDD_PULSE = 0; VDD_RISE = 1u
    Outputs: VDC("/BG_REF")
  TRAN_VDD (off): FBIAS/fecg_bandgap_tb/schematic, simulator spectre
    Variables: VDD = 3.3; VDD_PULSE = 20m; VDD_RISE = 1u
    Outputs: VT("/BG_REF")
  TRAN_VDD_MC (off): FBIAS/fecg_bandgap_tb/schematic, simulator spectre
    Variables: VDD = 0; VDD_PULSE = 3.3; VDD_RISE = 1u
    Outputs: VT("/BG_REF")
  DC_TEMP (off): FBIAS/fecg_bandgap_tb/schematic, simulator spectre
    Variables: VDD = 3.3; VDD_PULSE = 0; VDD_RISE = 1u
    Outputs: VDC("/BG_REF")
Corners (all switched off):
  model folders: /opt/pdk/ams/410/spectre/c35
  every corner: /opt/pdk/ams/410/spectre/c35/processOption.scs, /opt/pdk/ams/410/spectre/c35/cmos53.scs[cmoswo cmoswp cmosws cmoswz], /opt/pdk/ams/410/spectre/c35/ind.scs[indtm], /opt/pdk/ams/410/spectre/c35/esddiode.scs[esddiodetm]
  CMOS (off): res.scs[restm], cap.scs[captm], bip.scs[biptm]
  CMOS_VDD (off): VDD=2.97 3.63; res.scs[restm], cap.scs[captm], bip.scs[biptm]
  CMOS_VDD_TEMP (off): temperature=-40 85; VDD=2.97 3.63; res.scs[restm], cap.scs[captm], bip.scs[biptm]
  CMOS_RES_CAP_VDD_TEMP (off): temperature=-40 85; VDD=2.97 3.63; res.scs[reswp resws], cap.scs[capwp capws], bip.scs[biptm]
  CMOS_RES_CAP_TEMP (off): temperature=-40 85; res.scs[reswp resws], cap.scs[capwp capws], bip.scs[biptm]
  CMOS_RES_BIP_VDD_TEMP (off): temperature=-40 85; VDD=2.97 3.63; res.scs[reswp resws], cap.scs[captm], bip.scs[biphb biphs biplb]
  CMOS_RES_BIP_TEMP (off): temperature=-40 85; res.scs[reswp resws], cap.scs[captm], bip.scs[biphb biphs biplb]
  CMOS_RES_CAP_BIP_TEMP: temperature=-40 85; res.scs[reswp resws], cap.scs[capwp capws], bip.scs[biphb biphs biplb]
