ADE simulation setup
Run mode: Single Run, Sweeps and Corners
Tests:
  DC (off): FBIAS/fbias_por_tb/schematic, simulator spectre
    Variables: VDD_STEP = 0; VDD_TR = 1u; VDD = 3.3; VDD_BOR = 0
    Outputs: VDC("/VBG"); IDC("/I2/BIAS"); IDC("/I0/BIAS")
  TRAN: FBIAS/fbias_por_tb/schematic, simulator spectre
    Variables: VDD_STEP = 3.3; VDD_TR = 1u; VDD = 0; VDD_BOR = -500m
    Outputs: /POR_L; /VBG; /VDD; /IPRB0/MINUS; /I0/VY; BIAS_BG
  DC_MC (off): FBIAS/fbias_por_tb/schematic, simulator spectre
    Variables: VDD_STEP = 0; VDD_TR = 1u; VDD = 3.3; VDD_BOR = 0
    Outputs: VDC("/VBG"); IDC("/I2/BIAS")
  TRAN_MC (off): FBIAS/fbias_por_tb/schematic, simulator spectre
    Variables: VDD_STEP = 3.3; VDD_TR = 1u; VDD = 0; VDD_BOR = 0
    Outputs: /POR_L; /VBG; /VDD; /IPRB0/MINUS
Corners:
  model folders: /opt/pdk/ams/410/spectre/c35
  every corner: /opt/pdk/ams/410/spectre/c35/processOption.scs, /opt/pdk/ams/410/spectre/c35/cmos53.scs[cmoswo cmoswp cmosws cmoswz], /opt/pdk/ams/410/spectre/c35/ind.scs[indtm], /opt/pdk/ams/410/spectre/c35/esddiode.scs[esddiodetm]
  CMOS (off): res.scs[restm], cap.scs[captm], bip.scs[biptm]
  CMOS_VDD (off): VDD=2.97 3.63; res.scs[restm], cap.scs[captm], bip.scs[biptm]
  CMOS_VDD_TEMP (off): temperature=-40 85; VDD=2.97 3.63; res.scs[restm], cap.scs[captm], bip.scs[biptm]
  CMOS_RES_CAP_VDD_TEMP (off): temperature=-40 85; VDD=2.97 3.63; res.scs[reswp resws], cap.scs[capwp capws], bip.scs[biptm]
  CMOS_RES_CAP_TEMP (off): temperature=-40 85; res.scs[reswp resws], cap.scs[capwp capws], bip.scs[biptm]
  CMOS_RES_BIP_VDD_TEMP (off): temperature=-40 85; VDD=2.97 3.63; res.scs[reswp resws], cap.scs[captm], bip.scs[biphb biphs biplb]
  CMOS_RES_BIP_TEMP (off): temperature=-40 85; res.scs[reswp resws], cap.scs[captm], bip.scs[biphb biphs biplb]
  CMOS_RES_CAP_BIP_TEMP: temperature=-40 85; res.scs[reswp resws], cap.scs[capwp capws], bip.scs[biphb biphs biplb]
  CMOS_RES_CAP_BIP_VDD_TEMP (off): temperature=-40 85; VDD=2.97 3.63; res.scs[reswp resws], cap.scs[capwp capws], bip.scs[biphb biphs biplb]
