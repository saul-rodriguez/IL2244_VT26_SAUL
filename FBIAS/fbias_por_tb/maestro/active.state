ADE simulation setup
Test TRAN: FBIAS/fbias_por_tb/schematic, simulator spectre
  Models: /opt/pdk/ams/410/spectre/c35/processOption.scs, /opt/pdk/ams/410/spectre/c35/cmos53.scs[cmostm], /opt/pdk/ams/410/spectre/c35/res.scs[restm], /opt/pdk/ams/410/spectre/c35/cap.scs[captm], /opt/pdk/ams/410/spectre/c35/bip.scs[biptm], /opt/pdk/ams/410/spectre/c35/ind.scs[indtm], /opt/pdk/ams/410/spectre/c35/esddiode.scs[esddiodetm]
  Variables: VDD = 0; VDD_STEP = 3.3; VDD_TR = 1u
  Temperature: 27
  Simulator options: reltol=100e-6 homotopy=all limit=delta additionalArgs=enable_pre_ver=yes ignorezerovar=yes
  Files: definitions /opt/pdk/ams/410/spectre/c35/soac/soac.scs
  Analysis tran: stop=500m errpreset=conservative
  Signals: /POR_L, /VBG, /VDD, /IPRB0/MINUS (terminal)
Test TRAN_MC: FBIAS/fbias_por_tb/schematic, simulator spectre
  Models: /opt/pdk/ams/410/spectre/c35/processOption.scs, /opt/pdk/ams/410/spectre/c35/cmos53.scs[cmosmc], /opt/pdk/ams/410/spectre/c35/res.scs[resmc], /opt/pdk/ams/410/spectre/c35/cap.scs[capmc], /opt/pdk/ams/410/spectre/c35/bip.scs[bipmc], /opt/pdk/ams/410/spectre/c35/ind.scs[indmc], /opt/pdk/ams/410/spectre/c35/esddiode.scs[esddiodemc]
  Variables: VDD = 0; VDD_STEP = 3.3; VDD_TR = 1u
  Temperature: 27
  Simulator options: reltol=100e-6 homotopy=all limit=delta additionalArgs=enable_pre_ver=yes ignorezerovar=yes
  Files: definitions /opt/pdk/ams/410/spectre/c35/soac/soac.scs
  Analysis tran: stop=500m errpreset=conservative
  Signals: /POR_L, /VBG, /VDD, /IPRB0/MINUS (terminal)
Test DC_MC: FBIAS/fbias_por_tb/schematic, simulator spectre
  Models: /opt/pdk/ams/410/spectre/c35/processOption.scs, /opt/pdk/ams/410/spectre/c35/cmos53.scs[cmosmc], /opt/pdk/ams/410/spectre/c35/res.scs[resmc], /opt/pdk/ams/410/spectre/c35/cap.scs[capmc], /opt/pdk/ams/410/spectre/c35/bip.scs[bipmc], /opt/pdk/ams/410/spectre/c35/ind.scs[indmc], /opt/pdk/ams/410/spectre/c35/esddiode.scs[esddiodemc]
  Variables: VDD = 3.3; VDD_STEP = 0; VDD_TR = 1u
  Temperature: 27
  Simulator options: reltol=100e-6 homotopy=all limit=delta additionalArgs=enable_pre_ver=yes ignorezerovar=yes
  Files: definitions /opt/pdk/ams/410/spectre/c35/soac/soac.scs
  Analysis dc: (saves the operating point)
  Analysis xf: start=0.01 stop=100M dec=20 p=/VBG
  Output VDC("/VBG")
  Output IDC("/I2/BIAS")
  Output V/V /V0; xf dB20(V/V) = db(getData("/V0" ?result "xf"))
  Signals: /VBG, /I2/BIAS (terminal)
Test DC: FBIAS/fbias_por_tb/schematic, simulator spectre
  Models: /opt/pdk/ams/410/spectre/c35/processOption.scs, /opt/pdk/ams/410/spectre/c35/cmos53.scs[cmostm], /opt/pdk/ams/410/spectre/c35/res.scs[restm], /opt/pdk/ams/410/spectre/c35/cap.scs[captm], /opt/pdk/ams/410/spectre/c35/bip.scs[biptm], /opt/pdk/ams/410/spectre/c35/ind.scs[indtm], /opt/pdk/ams/410/spectre/c35/esddiode.scs[esddiodetm]
  Variables: VDD = 3.3; VDD_STEP = 0; VDD_TR = 1u
  Temperature: 27
  Simulator options: reltol=100e-6 homotopy=all limit=delta additionalArgs=enable_pre_ver=yes ignorezerovar=yes
  Files: definitions /opt/pdk/ams/410/spectre/c35/soac/soac.scs
  Analysis dc: (saves the operating point)
  Analysis xf: start=0.01 stop=100M dec=20 p=/VBG
  Output VDC("/VBG")
  Output IDC("/I2/BIAS")
  Output IDC("/I0/BIAS")
  Output V/V /V0; xf dB20(V/V) = db(getData("/V0" ?result "xf"))
  Signals: /VBG, /I2/BIAS (terminal), /I0/BIAS (terminal)
Run mode: Single Run, Sweeps and Corners
Corners:
  model folders: /opt/pdk/ams/410/spectre/c35
  every corner: /opt/pdk/ams/410/spectre/c35/processOption.scs, /opt/pdk/ams/410/spectre/c35/cmos53.scs[cmoswo cmoswp cmosws cmoswz], /opt/pdk/ams/410/spectre/c35/ind.scs[indtm], /opt/pdk/ams/410/spectre/c35/esddiode.scs[esddiodetm]
  CMOS (off): res.scs[restm], cap.scs[captm], bip.scs[biptm]
  CMOS_VDD (off): VDD=2.97 3.63; res.scs[restm], cap.scs[captm], bip.scs[biptm]
  CMOS_VDD_TEMP (off): temperature=-40 85; VDD=2.97 3.63; res.scs[restm], cap.scs[captm], bip.scs[biptm]
  CMOS_RES_CAP_VDD_TEMP (off): temperature=-40 85; VDD=2.97 3.63; res.scs[reswp resws], cap.scs[capwp capws], bip.scs[biptm]
  CMOS_RES_CAP_TEMP: temperature=-40 85; res.scs[reswp resws], cap.scs[capwp capws], bip.scs[biptm]
  CMOS_RES_BIP_VDD_TEMP (off): temperature=-40 85; VDD=2.97 3.63; res.scs[reswp resws], cap.scs[captm], bip.scs[biphb biphs biplb]
  CMOS_RES_BIP_TEMP (off): temperature=-40 85; res.scs[reswp resws], cap.scs[captm], bip.scs[biphb biphs biplb]
  CMOS_RES_CAP_BIP_TEMP (off): temperature=-40 85; res.scs[reswp resws], cap.scs[capwp capws], bip.scs[biphb biphs biplb]
  CMOS_RES_CAP_BIP_VDD_TEMP (off): temperature=-40 85; VDD=2.97 3.63; res.scs[reswp resws], cap.scs[capwp capws], bip.scs[biphb biphs biplb]
Setup values for test DC: VDD_BOR = 0
Setup values for test TRAN: VDD_BOR = -500m
Setup values for test DC_MC: VDD_BOR = 0
Setup values for test TRAN_MC: VDD_BOR = 0
Disabled tests: DC_MC, TRAN, TRAN_1, TRAN_MC
