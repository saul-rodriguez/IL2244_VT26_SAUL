ADE simulation setup
Test DC: FBIAS/fbias_por_tb/schematic, simulator spectre
  Models: /opt/pdk/ams/410/spectre/c35/processOption.scs, /opt/pdk/ams/410/spectre/c35/cmos53.scs[cmostm], /opt/pdk/ams/410/spectre/c35/res.scs[restm], /opt/pdk/ams/410/spectre/c35/cap.scs[captm], /opt/pdk/ams/410/spectre/c35/bip.scs[biptm], /opt/pdk/ams/410/spectre/c35/ind.scs[indtm], /opt/pdk/ams/410/spectre/c35/esddiode.scs[esddiodetm]
  Variables: VDD_BOR = 0; VDD = 3.3; VDD_STEP = 0; VDD_TR = 1u
  Temperature: 27
  Simulator options: reltol=100e-6 homotopy=all limit=delta additionalArgs=enable_pre_ver=yes ignorezerovar=yes
  Files: definitions /opt/pdk/ams/410/spectre/c35/soac/soac.scs
  Analysis dc: (saves the operating point)
  Analysis xf: start=0.01 stop=100M dec=20 p=/VBG
  Output VDC("/VBG")
  Output IDC("/I2/BIAS")
  Output IDC("/I0/BIAS")
  Output V/V /V0; xf dB20(V/V) = db(getData("/V0" ?result "xf"))
  Signals: /VBG, /I2/BIAS (terminal), /I0/BIAS (terminal)
Test TRAN: FBIAS/fbias_por_tb/schematic, simulator spectre
  Models: /opt/pdk/ams/410/spectre/c35/processOption.scs, /opt/pdk/ams/410/spectre/c35/cmos53.scs[cmostm], /opt/pdk/ams/410/spectre/c35/res.scs[restm], /opt/pdk/ams/410/spectre/c35/cap.scs[captm], /opt/pdk/ams/410/spectre/c35/bip.scs[biptm], /opt/pdk/ams/410/spectre/c35/ind.scs[indtm], /opt/pdk/ams/410/spectre/c35/esddiode.scs[esddiodetm]
  Variables: VDD_BOR = -300m; VDD = 0; VDD_STEP = 3.3; VDD_TR = 1u
  Temperature: 27
  Simulator options: reltol=100e-6 homotopy=all limit=delta additionalArgs=enable_pre_ver=yes ignorezerovar=yes
  Files: definitions /opt/pdk/ams/410/spectre/c35/soac/soac.scs
  Analysis tran: stop=1 errpreset=conservative
  Signals: /POR_L, /VBG, /VDD, /IPRB0/MINUS (terminal), /I0/VY, /I2/BIAS (terminal) as BIAS_BG
Test DC_MC: FBIAS/fbias_por_tb/schematic, simulator spectre
  Models: /opt/pdk/ams/410/spectre/c35/processOption.scs, /opt/pdk/ams/410/spectre/c35/cmos53.scs[cmosmc], /opt/pdk/ams/410/spectre/c35/res.scs[resmc], /opt/pdk/ams/410/spectre/c35/cap.scs[capmc], /opt/pdk/ams/410/spectre/c35/bip.scs[bipmc], /opt/pdk/ams/410/spectre/c35/ind.scs[indmc], /opt/pdk/ams/410/spectre/c35/esddiode.scs[esddiodemc]
  Variables: VDD_BOR = 0; VDD = 3.3; VDD_STEP = 0; VDD_TR = 1u
  Temperature: 27
  Simulator options: reltol=100e-6 homotopy=all limit=delta additionalArgs=enable_pre_ver=yes ignorezerovar=yes
  Files: definitions /opt/pdk/ams/410/spectre/c35/soac/soac.scs
  Analysis dc: (saves the operating point)
  Analysis xf: start=0.01 stop=100M dec=20 p=/VBG
  Output VDC("/VBG")
  Output IDC("/I2/BIAS")
  Output V/V /V0; xf dB20(V/V) = db(getData("/V0" ?result "xf"))
  Signals: /VBG, /I2/BIAS (terminal)
Test TRAN_MC: FBIAS/fbias_por_tb/schematic, simulator spectre
  Models: /opt/pdk/ams/410/spectre/c35/processOption.scs, /opt/pdk/ams/410/spectre/c35/cmos53.scs[cmosmc], /opt/pdk/ams/410/spectre/c35/res.scs[resmc], /opt/pdk/ams/410/spectre/c35/cap.scs[capmc], /opt/pdk/ams/410/spectre/c35/bip.scs[bipmc], /opt/pdk/ams/410/spectre/c35/ind.scs[indmc], /opt/pdk/ams/410/spectre/c35/esddiode.scs[esddiodemc]
  Variables: VDD_BOR = 0; VDD = 0; VDD_STEP = 3.3; VDD_TR = 1u
  Temperature: 27
  Simulator options: reltol=100e-6 homotopy=all limit=delta additionalArgs=enable_pre_ver=yes ignorezerovar=yes
  Files: definitions /opt/pdk/ams/410/spectre/c35/soac/soac.scs
  Analysis tran: stop=500m errpreset=conservative
  Signals: /POR_L, /VBG, /VDD, /IPRB0/MINUS (terminal)
