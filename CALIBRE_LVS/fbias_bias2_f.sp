* SPICE NETLIST
***************************************

.SUBCKT tsv80 TOP BOTTOM SUB
.ENDS
***************************************
.SUBCKT rx POS NEG
.ENDS
***************************************
.SUBCKT Q C B E S G
.ENDS
***************************************
.SUBCKT lddn D G S B
.ENDS
***************************************
.SUBCKT phd POS NEG P
.ENDS
***************************************
.SUBCKT sbd A C SUB
.ENDS
***************************************
.SUBCKT esddlv2 A C
.ENDS
***************************************
.SUBCKT esddlv A C SUB
.ENDS
***************************************
.SUBCKT lddp D G S B
.ENDS
***************************************
.SUBCKT probepad pad
.ENDS
***************************************
.SUBCKT L POS NEG SUB
.ENDS
***************************************
.SUBCKT L POS NEG MID SUB
.ENDS
***************************************
.SUBCKT hall A B C D S P1 P2
.ENDS
***************************************
.SUBCKT V200_20 VDD GND
** N=2 EP=2 IP=0 FDC=1
C0 GND VDD $[cpolya] $A=3790.5 $P=419.9 $X=5575 $Y=3100 $D=58
.ENDS
***************************************
.SUBCKT cvar_CDNS_780038168285 1 2
** N=2 EP=2 IP=0 FDC=2
M0 2 1 2 1 cvar w=0.000792 l=6.5e-07 cols=12 rows=10 $X=0 $Y=0 $D=62
D1 1 2 p_nwd AREA=1709.1 PJ=204.2 $X=-300 $Y=-300 $D=87
.ENDS
***************************************
.SUBCKT nmos4_CDNS_780038168284
** N=4 EP=0 IP=0 FDC=0
.ENDS
***************************************
.SUBCKT ICV_1 3 4 5
** N=5 EP=3 IP=8 FDC=1
M0 4 5 3 3 nmos4 L=1e-05 W=5e-06 AD=4.25e-12 AS=4.25e-12 PD=6.7e-06 PS=6.7e-06 NRD=0.085 NRS=0.085 $X=6250 $Y=850 $D=37
.ENDS
***************************************
.SUBCKT pmos4_CDNS_780038168280
** N=5 EP=0 IP=0 FDC=0
.ENDS
***************************************
.SUBCKT ICV_2
** N=7 EP=0 IP=10 FDC=0
.ENDS
***************************************
.SUBCKT ICV_3 3 4 5 6
** N=6 EP=4 IP=10 FDC=3
M0 5 6 3 3 nmos4 L=1e-05 W=5e-06 AD=4.25e-12 AS=4.25e-12 PD=6.7e-06 PS=6.7e-06 NRD=0.085 NRS=0.085 $X=12500 $Y=850 $D=37
X1 3 4 6 ICV_1 $T=0 0 0 0 $X=-400 $Y=-250
X2 3 6 6 ICV_1 $T=12500 0 0 0 $X=12100 $Y=-250
.ENDS
***************************************
.SUBCKT P1_C_CDNS_7800381682822
** N=2 EP=0 IP=0 FDC=0
.ENDS
***************************************
.SUBCKT nmos4_CDNS_780038168286 1 2 3
** N=3 EP=3 IP=0 FDC=1
M0 2 3 1 1 nmos4 L=1e-05 W=1e-05 AD=8.5e-12 AS=8.5e-12 PD=1.17e-05 PS=1.17e-05 NRD=0.0425 NRS=0.0425 $X=0 $Y=850 $D=37
.ENDS
***************************************
.SUBCKT ICV_4 2 3 4 5 6
** N=7 EP=5 IP=14 FDC=3
M0 2 6 3 3 pmos4 L=1e-05 W=5e-06 AD=4.25e-12 AS=4.25e-12 PD=6.7e-06 PS=6.7e-06 NRD=0.085 NRS=0.085 $X=6250 $Y=850 $D=41
M1 4 6 3 3 pmos4 L=1e-05 W=5e-06 AD=4.25e-12 AS=4.25e-12 PD=6.7e-06 PS=6.7e-06 NRD=0.085 NRS=0.085 $X=12500 $Y=850 $D=41
M2 5 6 3 3 pmos4 L=1e-05 W=5e-06 AD=4.25e-12 AS=4.25e-12 PD=6.7e-06 PS=6.7e-06 NRD=0.085 NRS=0.085 $X=18750 $Y=850 $D=41
.ENDS
***************************************
.SUBCKT pmos4_CDNS_780038168287
** N=5 EP=0 IP=0 FDC=0
.ENDS
***************************************
.SUBCKT ICV_5
** N=7 EP=0 IP=10 FDC=0
.ENDS
***************************************
.SUBCKT P1_C_CDNS_7800381682830
** N=2 EP=0 IP=0 FDC=0
.ENDS
***************************************
.SUBCKT cvar_CDNS_780038168282 1 2
** N=2 EP=2 IP=0 FDC=2
M0 2 1 2 1 cvar w=0.0003696 l=6.5e-07 cols=8 rows=7 $X=0 $Y=0 $D=62
D1 1 2 p_nwd AREA=817.8 PJ=141.8 $X=-300 $Y=-300 $D=87
.ENDS
***************************************
.SUBCKT fbias_por2_f GNDA BIAS VDDA VBG POR_L
** N=13 EP=5 IP=118 FDC=69
R0 GNDA 12 L=0.00099985 W=8e-07 $[rpolyh] $X=84750 $Y=50650 $D=18
R1 12 VDDA L=0.00139975 W=8e-07 $[rpolyh] $X=84750 $Y=112600 $D=18
M2 BIAS GNDA BIAS GNDA cvar w=0.0002772 l=6.5e-07 cols=7 rows=6 $X=60750 $Y=51950 $D=62
D3 GNDA VDDA p_nwd AREA=1899.48 PJ=196.7 $X=1700 $Y=116750 $D=87
D4 GNDA VDDA p_nwd AREA=638.715 PJ=101.3 $X=7325 $Y=88800 $D=87
D5 GNDA VDDA p_nwd AREA=1457.68 PJ=161.2 $X=9800 $Y=145900 $D=87
D6 GNDA BIAS p_nwd AREA=619.37 PJ=122.1 $X=60450 $Y=51650 $D=87
D7 GNDA GNDA p_nwd AREA=6421.88 PJ=390.6 $X=77600 $Y=42500 $D=87
D8 GNDA VDDA p_nwd AREA=45.625 PJ=27.1 $X=109550 $Y=17550 $D=87
M9 BIAS BIAS BIAS GNDA nmos4 L=1e-05 W=5e-06 AD=4.25e-12 AS=4.25e-12 PD=6.7e-06 PS=6.7e-06 NRD=0.085 NRS=0.085 $X=18475 $Y=14650 $D=38
M10 BIAS BIAS BIAS GNDA nmos4 L=1e-05 W=5e-06 AD=4.25e-12 AS=4.25e-12 PD=6.7e-06 PS=6.7e-06 NRD=0.085 NRS=0.085 $X=80975 $Y=14650 $D=38
M11 7 BIAS GNDA GNDA nmos4 L=1e-05 W=5e-06 AD=4.25e-12 AS=4.25e-12 PD=6.7e-06 PS=6.7e-06 NRD=0.085 NRS=0.085 $X=43475 $Y=14650 $D=37
M12 7 BIAS GNDA GNDA nmos4 L=1e-05 W=5e-06 AD=4.25e-12 AS=4.25e-12 PD=6.7e-06 PS=6.7e-06 NRD=0.085 NRS=0.085 $X=68475 $Y=14650 $D=37
M13 9 6 GNDA GNDA nmos4 L=1e-06 W=2.5e-06 AD=1.25e-12 AS=2.125e-12 PD=1e-06 PS=4.2e-06 NRD=0.17 NRS=0.17 $X=95150 $Y=20800 $D=37
M14 GNDA 6 9 GNDA nmos4 L=1e-06 W=2.5e-06 AD=1.25e-12 AS=1.25e-12 PD=1e-06 PS=1e-06 NRD=0.17 NRS=0.17 $X=97150 $Y=20800 $D=37
M15 9 6 GNDA GNDA nmos4 L=1e-06 W=2.5e-06 AD=1.25e-12 AS=1.25e-12 PD=1e-06 PS=1e-06 NRD=0.17 NRS=0.17 $X=99150 $Y=20800 $D=37
M16 GNDA 6 9 GNDA nmos4 L=1e-06 W=2.5e-06 AD=2.125e-12 AS=1.25e-12 PD=4.2e-06 PS=1e-06 NRD=0.17 NRS=0.17 $X=101150 $Y=20800 $D=37
M17 13 9 GNDA GNDA nmos4 L=3.5e-07 W=4e-07 AD=5.7e-13 AS=1.45e-12 PD=2.8e-06 PS=6.5e-06 NRD=1.0625 NRS=1.0625 $X=111500 $Y=15800 $D=37
M18 POR_L 13 GNDA GNDA nmos4 L=3.5e-07 W=8e-07 AD=6.8e-13 AS=1.11e-12 PD=2.5e-06 PS=5.3e-06 NRD=0.53125 NRS=0.53125 $X=114350 $Y=15550 $D=37
M19 7 7 7 VDDA pmos4 L=1e-05 W=5e-06 AD=4.25e-12 AS=4.25e-12 PD=6.7e-06 PS=6.7e-06 NRD=0.085 NRS=0.085 $X=7050 $Y=125950 $D=42
M20 11 11 11 VDDA pmos4 L=5e-07 W=5e-06 AD=4.25e-12 AS=4.25e-12 PD=6.7e-06 PS=6.7e-06 NRD=0.085 NRS=0.085 $X=13550 $Y=100150 $D=42
M21 8 8 8 VDDA pmos4 L=1e-05 W=5e-06 AD=4.25e-12 AS=4.25e-12 PD=6.7e-06 PS=6.7e-06 NRD=0.085 NRS=0.085 $X=15150 $Y=153100 $D=42
M22 11 11 11 VDDA pmos4 L=5e-07 W=5e-06 AD=4.25e-12 AS=4.25e-12 PD=6.7e-06 PS=6.7e-06 NRD=0.085 NRS=0.085 $X=27550 $Y=100150 $D=42
M23 8 8 8 VDDA pmos4 L=1e-05 W=5e-06 AD=4.25e-12 AS=4.25e-12 PD=6.7e-06 PS=6.7e-06 NRD=0.085 NRS=0.085 $X=52650 $Y=153100 $D=42
M24 7 7 7 VDDA pmos4 L=1e-05 W=5e-06 AD=4.25e-12 AS=4.25e-12 PD=6.7e-06 PS=6.7e-06 NRD=0.085 NRS=0.085 $X=63300 $Y=125950 $D=42
M25 10 VBG 11 VDDA pmos4 L=5e-07 W=5e-06 AD=4.25e-12 AS=4.25e-12 PD=6.7e-06 PS=6.7e-06 NRD=0.085 NRS=0.085 $X=16350 $Y=100150 $D=41
M26 6 12 11 VDDA pmos4 L=5e-07 W=5e-06 AD=4.25e-12 AS=4.25e-12 PD=6.7e-06 PS=6.7e-06 NRD=0.085 NRS=0.085 $X=19150 $Y=100150 $D=41
M27 10 VBG 11 VDDA pmos4 L=5e-07 W=5e-06 AD=4.25e-12 AS=4.25e-12 PD=6.7e-06 PS=6.7e-06 NRD=0.085 NRS=0.085 $X=21950 $Y=100150 $D=41
M28 6 12 11 VDDA pmos4 L=5e-07 W=5e-06 AD=4.25e-12 AS=4.25e-12 PD=6.7e-06 PS=6.7e-06 NRD=0.085 NRS=0.085 $X=24750 $Y=100150 $D=41
M29 VDDA 7 11 VDDA pmos4 L=1e-05 W=5e-06 AD=4.25e-12 AS=4.25e-12 PD=6.7e-06 PS=6.7e-06 NRD=0.085 NRS=0.085 $X=32050 $Y=125950 $D=41
M30 8 8 VDDA VDDA pmos4 L=1e-05 W=5e-06 AD=4.25e-12 AS=4.25e-12 PD=6.7e-06 PS=6.7e-06 NRD=0.085 NRS=0.085 $X=40150 $Y=153100 $D=41
M31 8 8 VDDA VDDA pmos4 L=1e-05 W=5e-06 AD=4.25e-12 AS=4.25e-12 PD=6.7e-06 PS=6.7e-06 NRD=0.085 NRS=0.085 $X=46400 $Y=153100 $D=41
M32 VDDA 7 7 VDDA pmos4 L=1e-05 W=5e-06 AD=4.25e-12 AS=4.25e-12 PD=6.7e-06 PS=6.7e-06 NRD=0.085 NRS=0.085 $X=57050 $Y=125950 $D=41
M33 13 9 VDDA VDDA pmos4 L=3.5e-07 W=7e-07 AD=5.95e-13 AS=1.19e-12 PD=2.4e-06 PS=4.1e-06 NRD=0.607143 NRS=0.607143 $X=111650 $Y=18750 $D=41
M34 POR_L 13 VDDA VDDA pmos4 L=3.5e-07 W=1.4e-06 AD=9.45e-13 AS=1.47e-12 PD=3.1e-06 PS=3.8e-06 NRD=0.303571 NRS=0.303571 $X=114450 $Y=18750 $D=41
X35 GNDA 9 cvar_CDNS_780038168285 $T=125750 26550 0 0 $X=123475 $Y=25000
X36 GNDA 9 cvar_CDNS_780038168285 $T=125750 114300 0 0 $X=123475 $Y=112750
X37 GNDA 9 cvar_CDNS_780038168285 $T=152200 26550 0 0 $X=149925 $Y=25000
X38 GNDA 9 cvar_CDNS_780038168285 $T=152200 114300 0 0 $X=149925 $Y=112750
X39 GNDA 9 cvar_CDNS_780038168285 $T=178650 26550 0 0 $X=176375 $Y=25000
X40 GNDA 9 cvar_CDNS_780038168285 $T=178650 114300 0 0 $X=176375 $Y=112750
X42 GNDA BIAS BIAS ICV_1 $T=68475 13800 0 0 $X=68075 $Y=13550
X46 GNDA BIAS 7 BIAS ICV_3 $T=18475 13800 0 0 $X=18075 $Y=13550
X47 GNDA 8 7 BIAS ICV_3 $T=43475 13800 0 0 $X=43075 $Y=13550
X50 GNDA 10 10 nmos4_CDNS_780038168286 $T=18875 61100 0 270 $X=18625 $Y=50700
X51 GNDA 6 10 nmos4_CDNS_780038168286 $T=18875 75600 0 270 $X=18625 $Y=65200
X52 GNDA 6 10 nmos4_CDNS_780038168286 $T=31175 61100 0 270 $X=30925 $Y=50700
X53 GNDA 10 10 nmos4_CDNS_780038168286 $T=31175 75600 0 270 $X=30925 $Y=65200
X54 7 VDDA 11 7 7 ICV_4 $T=7050 136800 1 0 $X=5850 $Y=123900
X55 8 VDDA 8 9 8 ICV_4 $T=15150 152250 0 0 $X=13950 $Y=151050
X56 11 VDDA 7 11 7 ICV_4 $T=32050 136800 1 0 $X=30850 $Y=123900
X63 GNDA VDDA cvar_CDNS_780038168282 $T=13300 176675 1 90 $X=11750 $Y=174400
.ENDS
***************************************
.SUBCKT V500_20 VDD GND
** N=2 EP=2 IP=0 FDC=1
C0 GND VDD $[cpolya] $A=9800 $P=1020 $X=2150 $Y=3100 $D=58
.ENDS
***************************************
.SUBCKT cvar_CDNS_7800381682823 1 2
** N=2 EP=2 IP=0 FDC=2
M0 2 1 2 1 cvar w=0.00066 l=6.5e-07 cols=10 rows=10 $X=0 $Y=0 $D=62
D1 1 2 p_nwd AREA=1441.8 PJ=197.6 $X=-300 $Y=-300 $D=87
.ENDS
***************************************
.SUBCKT pmos4_CDNS_7800381682819
** N=5 EP=0 IP=0 FDC=0
.ENDS
***************************************
.SUBCKT ICV_6
** N=7 EP=0 IP=10 FDC=0
.ENDS
***************************************
.SUBCKT ICV_7 3 4 5 8
** N=9 EP=4 IP=14 FDC=2
M0 4 8 3 3 pmos4 L=2e-05 W=4e-06 AD=3.4e-12 AS=3.4e-12 PD=5.7e-06 PS=5.7e-06 NRD=0.10625 NRS=0.10625 $X=5250 $Y=850 $D=41
M1 5 8 3 3 pmos4 L=2e-05 W=4e-06 AD=3.4e-12 AS=3.4e-12 PD=5.7e-06 PS=5.7e-06 NRD=0.10625 NRS=0.10625 $X=10500 $Y=850 $D=41
.ENDS
***************************************
.SUBCKT pmos4_CDNS_7800381682820 1 2 3 5
** N=5 EP=4 IP=0 FDC=1
M0 2 3 1 5 pmos4 L=1e-06 W=5e-06 AD=4.25e-12 AS=4.25e-12 PD=6.7e-06 PS=6.7e-06 NRD=0.085 NRS=0.085 $X=0 $Y=850 $D=41
.ENDS
***************************************
.SUBCKT P1_C_CDNS_78003816828103
** N=2 EP=0 IP=0 FDC=0
.ENDS
***************************************
.SUBCKT pmos4_CDNS_7800381682816 1 2 3 5
** N=5 EP=4 IP=0 FDC=1
M0 2 3 1 5 pmos4 L=2e-05 W=2e-05 AD=1.7e-11 AS=1.7e-11 PD=2.17e-05 PS=2.17e-05 NRD=0.02125 NRS=0.02125 $X=0 $Y=850 $D=41
.ENDS
***************************************
.SUBCKT nmos4_CDNS_7800381682821
** N=4 EP=0 IP=0 FDC=0
.ENDS
***************************************
.SUBCKT ICV_8
** N=6 EP=0 IP=8 FDC=0
.ENDS
***************************************
.SUBCKT P1_C_CDNS_78003816828100
** N=2 EP=0 IP=0 FDC=0
.ENDS
***************************************
.SUBCKT fbias_gm_c1_f2 OUT1 OUT4 OUT3 OUT2 GNDA VDDA
** N=18 EP=6 IP=157 FDC=60
R0 GNDA 16 L=0.00037505 W=2e-06 $[rpolyh] $X=118450 $Y=23450 $D=18
D1 GNDA VDDA p_nwd AREA=5133.78 PJ=381.7 $X=7050 $Y=167500 $D=87
D2 GNDA VDDA p_nwd AREA=3918.78 PJ=306.7 $X=7250 $Y=105000 $D=87
D3 GNDA GNDA p_nwd AREA=2175.26 PJ=188.2 $X=111400 $Y=16400 $D=87
D4 GNDA VDDA p_nwd AREA=96.32 PJ=39.6 $X=131600 $Y=76000 $D=87
M5 15 15 15 GNDA nmos4 L=2e-05 W=5e-06 AD=4.25e-12 AS=4.25e-12 PD=6.7e-06 PS=6.7e-06 NRD=0.085 NRS=0.085 $X=28650 $Y=26800 $D=38
M6 15 15 15 GNDA nmos4 L=2e-05 W=5e-06 AD=4.25e-12 AS=4.25e-12 PD=6.7e-06 PS=6.7e-06 NRD=0.085 NRS=0.085 $X=97400 $Y=26800 $D=38
M7 8 2 13 GNDA nmos4 L=2e-05 W=1e-05 AD=5e-12 AS=8.5e-12 PD=1e-06 PS=1.17e-05 NRD=0.0425 NRS=0.0425 $X=14875 $Y=68450 $D=37
M8 13 15 16 GNDA nmos4 L=2e-05 W=5e-06 AD=4.25e-12 AS=4.25e-12 PD=6.7e-06 PS=6.7e-06 NRD=0.085 NRS=0.085 $X=34900 $Y=26800 $D=37
M9 13 2 8 GNDA nmos4 L=2e-05 W=1e-05 AD=5e-12 AS=5e-12 PD=1e-06 PS=1e-06 NRD=0.0425 NRS=0.0425 $X=35875 $Y=68450 $D=37
M10 13 15 16 GNDA nmos4 L=2e-05 W=5e-06 AD=4.25e-12 AS=4.25e-12 PD=6.7e-06 PS=6.7e-06 NRD=0.085 NRS=0.085 $X=41150 $Y=26800 $D=37
M11 13 15 16 GNDA nmos4 L=2e-05 W=5e-06 AD=4.25e-12 AS=4.25e-12 PD=6.7e-06 PS=6.7e-06 NRD=0.085 NRS=0.085 $X=47400 $Y=26800 $D=37
M12 15 15 GNDA GNDA nmos4 L=2e-05 W=5e-06 AD=4.25e-12 AS=4.25e-12 PD=6.7e-06 PS=6.7e-06 NRD=0.085 NRS=0.085 $X=53650 $Y=26800 $D=37
M13 8 2 13 GNDA nmos4 L=2e-05 W=1e-05 AD=5e-12 AS=5e-12 PD=1e-06 PS=1e-06 NRD=0.0425 NRS=0.0425 $X=56875 $Y=68450 $D=37
M14 13 15 16 GNDA nmos4 L=2e-05 W=5e-06 AD=4.25e-12 AS=4.25e-12 PD=6.7e-06 PS=6.7e-06 NRD=0.085 NRS=0.085 $X=59900 $Y=26800 $D=37
M15 13 15 16 GNDA nmos4 L=2e-05 W=5e-06 AD=4.25e-12 AS=4.25e-12 PD=6.7e-06 PS=6.7e-06 NRD=0.085 NRS=0.085 $X=66150 $Y=26800 $D=37
M16 13 15 16 GNDA nmos4 L=2e-05 W=5e-06 AD=4.25e-12 AS=4.25e-12 PD=6.7e-06 PS=6.7e-06 NRD=0.085 NRS=0.085 $X=72400 $Y=26800 $D=37
M17 13 2 8 GNDA nmos4 L=2e-05 W=1e-05 AD=8.5e-12 AS=5e-12 PD=1.17e-05 PS=1e-06 NRD=0.0425 NRS=0.0425 $X=77875 $Y=68450 $D=37
M18 15 15 GNDA GNDA nmos4 L=2e-05 W=5e-06 AD=4.25e-12 AS=4.25e-12 PD=6.7e-06 PS=6.7e-06 NRD=0.085 NRS=0.085 $X=78650 $Y=26800 $D=37
M19 13 15 16 GNDA nmos4 L=2e-05 W=5e-06 AD=4.25e-12 AS=4.25e-12 PD=6.7e-06 PS=6.7e-06 NRD=0.085 NRS=0.085 $X=84900 $Y=26800 $D=37
M20 13 15 16 GNDA nmos4 L=2e-05 W=5e-06 AD=4.25e-12 AS=4.25e-12 PD=6.7e-06 PS=6.7e-06 NRD=0.085 NRS=0.085 $X=91150 $Y=26800 $D=37
M21 2 2 15 GNDA nmos4 L=2e-05 W=1e-05 AD=8.5e-12 AS=8.5e-12 PD=1.17e-05 PS=1.17e-05 NRD=0.0425 NRS=0.0425 $X=100675 $Y=68450 $D=37
M22 1 1 1 VDDA pmos4 L=2e-05 W=4e-06 AD=3.4e-12 AS=3.4e-12 PD=5.7e-06 PS=5.7e-06 NRD=0.10625 NRS=0.10625 $X=13400 $Y=173700 $D=42
M23 1 1 1 VDDA pmos4 L=2e-05 W=4e-06 AD=3.4e-12 AS=3.4e-12 PD=5.7e-06 PS=5.7e-06 NRD=0.10625 NRS=0.10625 $X=155150 $Y=173700 $D=42
M24 VDDA 1 5 VDDA pmos4 L=2e-05 W=4e-06 AD=3.4e-12 AS=3.4e-12 PD=5.7e-06 PS=5.7e-06 NRD=0.10625 NRS=0.10625 $X=29150 $Y=173700 $D=41
M25 VDDA 1 4 VDDA pmos4 L=2e-05 W=4e-06 AD=3.4e-12 AS=3.4e-12 PD=5.7e-06 PS=5.7e-06 NRD=0.10625 NRS=0.10625 $X=34400 $Y=173700 $D=41
M26 VDDA 1 1 VDDA pmos4 L=2e-05 W=4e-06 AD=3.4e-12 AS=3.4e-12 PD=5.7e-06 PS=5.7e-06 NRD=0.10625 NRS=0.10625 $X=50150 $Y=173700 $D=41
M27 VDDA 1 5 VDDA pmos4 L=2e-05 W=4e-06 AD=3.4e-12 AS=3.4e-12 PD=5.7e-06 PS=5.7e-06 NRD=0.10625 NRS=0.10625 $X=55400 $Y=173700 $D=41
M28 VDDA 1 6 VDDA pmos4 L=2e-05 W=4e-06 AD=3.4e-12 AS=3.4e-12 PD=5.7e-06 PS=5.7e-06 NRD=0.10625 NRS=0.10625 $X=71150 $Y=173700 $D=41
M29 VDDA 1 1 VDDA pmos4 L=2e-05 W=4e-06 AD=3.4e-12 AS=3.4e-12 PD=5.7e-06 PS=5.7e-06 NRD=0.10625 NRS=0.10625 $X=76400 $Y=173700 $D=41
M30 VDDA 1 4 VDDA pmos4 L=2e-05 W=4e-06 AD=3.4e-12 AS=3.4e-12 PD=5.7e-06 PS=5.7e-06 NRD=0.10625 NRS=0.10625 $X=92150 $Y=173700 $D=41
M31 VDDA 1 10 VDDA pmos4 L=2e-05 W=4e-06 AD=3.4e-12 AS=3.4e-12 PD=5.7e-06 PS=5.7e-06 NRD=0.10625 NRS=0.10625 $X=97400 $Y=173700 $D=41
M32 VDDA 1 5 VDDA pmos4 L=2e-05 W=4e-06 AD=3.4e-12 AS=3.4e-12 PD=5.7e-06 PS=5.7e-06 NRD=0.10625 NRS=0.10625 $X=113150 $Y=173700 $D=41
M33 VDDA 1 4 VDDA pmos4 L=2e-05 W=4e-06 AD=3.4e-12 AS=3.4e-12 PD=5.7e-06 PS=5.7e-06 NRD=0.10625 NRS=0.10625 $X=118400 $Y=173700 $D=41
M34 7 8 OUT4 VDDA pmos4 L=2e-05 W=4e-06 AD=3.4e-12 AS=3.4e-12 PD=5.7e-06 PS=5.7e-06 NRD=0.10625 NRS=0.10625 $X=118850 $Y=111200 $D=41
M35 VDDA 1 1 VDDA pmos4 L=2e-05 W=4e-06 AD=3.4e-12 AS=3.4e-12 PD=5.7e-06 PS=5.7e-06 NRD=0.10625 NRS=0.10625 $X=134150 $Y=173700 $D=41
M36 VDDA 1 5 VDDA pmos4 L=2e-05 W=4e-06 AD=3.4e-12 AS=3.4e-12 PD=5.7e-06 PS=5.7e-06 NRD=0.10625 NRS=0.10625 $X=139400 $Y=173700 $D=41
X37 GNDA VDDA cvar_CDNS_7800381682823 $T=161550 61500 1 180 $X=141725 $Y=59950
X39 VDDA 6 1 1 ICV_7 $T=13400 194550 1 0 $X=12200 $Y=171650
X40 VDDA 10 6 1 ICV_7 $T=34400 194550 1 0 $X=33200 $Y=171650
X41 VDDA 4 10 1 ICV_7 $T=55400 194550 1 0 $X=54200 $Y=171650
X42 VDDA 5 7 1 ICV_7 $T=76400 194550 1 0 $X=75200 $Y=171650
X43 VDDA 6 1 1 ICV_7 $T=97400 194550 1 0 $X=96200 $Y=171650
X44 VDDA 10 6 1 ICV_7 $T=118400 194550 1 0 $X=117200 $Y=171650
X45 VDDA 4 10 1 ICV_7 $T=139400 194550 1 0 $X=138200 $Y=171650
X46 8 18 18 VDDA pmos4_CDNS_7800381682820 $T=137800 77200 1 180 $X=131600 $Y=76000
X47 18 2 2 VDDA pmos4_CDNS_7800381682820 $T=137800 83300 1 180 $X=131600 $Y=82100
X53 1 8 8 VDDA pmos4_CDNS_7800381682816 $T=12600 132050 1 0 $X=11400 $Y=109150
X54 10 2 8 VDDA pmos4_CDNS_7800381682816 $T=33850 132050 1 0 $X=32650 $Y=109150
X55 4 OUT1 8 VDDA pmos4_CDNS_7800381682816 $T=55100 132050 1 0 $X=53900 $Y=109150
X56 5 OUT2 8 VDDA pmos4_CDNS_7800381682816 $T=76350 132050 1 0 $X=75150 $Y=109150
X57 6 OUT3 8 VDDA pmos4_CDNS_7800381682816 $T=97600 132050 1 0 $X=96400 $Y=109150
.ENDS
***************************************
.SUBCKT vert10_4 1 2
** N=2 EP=2 IP=0 FDC=1
Q0 2 2 1 pnpvert10 AREA=1e-12 $X=1400 $Y=1400 $D=33
.ENDS
***************************************
.SUBCKT rpolyhc_CDNS_7800381682811 1 2
** N=3 EP=2 IP=0 FDC=1
R0 1 2 L=5.255e-05 W=2e-06 $[rpolyh] $X=-2000 $Y=2750 $D=18
.ENDS
***************************************
.SUBCKT ICV_9 1 2 3 4
*.CALIBRE ICV_CELL 9
** N=5 EP=4 IP=6 FDC=2
X0 1 2 rpolyhc_CDNS_7800381682811 $T=0 0 0 0 $X=-7750 $Y=-5750
X1 3 4 rpolyhc_CDNS_7800381682811 $T=18050 0 0 0 $X=10300 $Y=-5750
.ENDS
***************************************
.SUBCKT ICV_10 1 2 3 4
*.CALIBRE ICV_CELL 9
** N=5 EP=4 IP=6 FDC=2
X0 1 2 rpolyhc_CDNS_7800381682811 $T=-18050 0 0 0 $X=-25800 $Y=-5750
X1 3 4 rpolyhc_CDNS_7800381682811 $T=0 0 0 0 $X=-7750 $Y=-5750
.ENDS
***************************************
.SUBCKT ICV_11 1 2 3
*.CALIBRE ICV_CELL 9
** N=3 EP=3 IP=4 FDC=2
X0 1 2 vert10_4 $T=0 0 0 0 $X=0 $Y=0
X1 3 2 vert10_4 $T=16900 0 0 0 $X=16900 $Y=0
.ENDS
***************************************
.SUBCKT ICV_12 1 2 3 4 5
*.CALIBRE ICV_CELL 9
** N=5 EP=5 IP=6 FDC=4
X0 1 2 3 ICV_11 $T=0 0 0 0 $X=0 $Y=0
X1 4 2 5 ICV_11 $T=33800 0 0 0 $X=33800 $Y=0
.ENDS
***************************************
.SUBCKT ND_C_CDNS_7800381682876
** N=2 EP=0 IP=0 FDC=0
.ENDS
***************************************
.SUBCKT P1_C_CDNS_7800381682856
** N=2 EP=0 IP=0 FDC=0
.ENDS
***************************************
.SUBCKT pmos4_CDNS_7800381682815
** N=4 EP=0 IP=0 FDC=0
.ENDS
***************************************
.SUBCKT P1_C_CDNS_7800381682868
** N=2 EP=0 IP=0 FDC=0
.ENDS
***************************************
.SUBCKT ND_C_CDNS_7800381682885
** N=2 EP=0 IP=0 FDC=0
.ENDS
***************************************
.SUBCKT P1_C_CDNS_7800381682847
** N=2 EP=0 IP=0 FDC=0
.ENDS
***************************************
.SUBCKT ND_C_CDNS_7800381682877
** N=2 EP=0 IP=0 FDC=0
.ENDS
***************************************
.SUBCKT pmos4_CDNS_7800381682814
** N=4 EP=0 IP=0 FDC=0
.ENDS
***************************************
.SUBCKT ICV_13
** N=6 EP=0 IP=8 FDC=0
.ENDS
***************************************
.SUBCKT ND_C_CDNS_7800381682878
** N=2 EP=0 IP=0 FDC=0
.ENDS
***************************************
.SUBCKT ICV_14 1 2 3 5 6
** N=8 EP=5 IP=12 FDC=3
M0 2 5 1 1 pmos4 L=4e-06 W=2.5e-05 AD=2.125e-11 AS=2.125e-11 PD=2.67e-05 PS=2.67e-05 NRD=0.017 NRS=0.017 $X=0 $Y=-18050 $D=41
M1 3 6 1 1 pmos4 L=4e-06 W=2.5e-05 AD=2.125e-11 AS=2.125e-11 PD=2.67e-05 PS=2.67e-05 NRD=0.017 NRS=0.017 $X=0 $Y=-11750 $D=41
M2 2 5 1 1 pmos4 L=4e-06 W=2.5e-05 AD=2.125e-11 AS=2.125e-11 PD=2.67e-05 PS=2.67e-05 NRD=0.017 NRS=0.017 $X=0 $Y=-5450 $D=41
.ENDS
***************************************
.SUBCKT P1_C_CDNS_7800381682851
** N=2 EP=0 IP=0 FDC=0
.ENDS
***************************************
.SUBCKT PD_C_CDNS_7800381682879
** N=1 EP=0 IP=0 FDC=0
.ENDS
***************************************
.SUBCKT ND_C_CDNS_7800381682869
** N=2 EP=0 IP=0 FDC=0
.ENDS
***************************************
.SUBCKT ICV_15
** N=6 EP=0 IP=10 FDC=0
.ENDS
***************************************
.SUBCKT ICV_16
** N=8 EP=0 IP=12 FDC=0
.ENDS
***************************************
.SUBCKT ICV_17 1
** N=9 EP=1 IP=27 FDC=2
M0 1 1 1 1 pmos4 L=1e-05 W=5e-06 AD=4.25e-12 AS=4.25e-12 PD=6.7e-06 PS=6.7e-06 NRD=0.085 NRS=0.085 $X=0 $Y=-122150 $D=42
M1 1 1 1 1 pmos4 L=1e-05 W=5e-06 AD=4.25e-12 AS=4.25e-12 PD=6.7e-06 PS=6.7e-06 NRD=0.085 NRS=0.085 $X=0 $Y=850 $D=42
.ENDS
***************************************
.SUBCKT fecg_bandgap3_layout BG_REF VDDA GNDA BIAS
** N=56 EP=4 IP=636 FDC=248
D0 GNDA VDDA p_nwd AREA=30907.1 PJ=704.2 $X=4250 $Y=202850 $D=87
D1 GNDA GNDA p_nwd AREA=4092.2 PJ=255.9 $X=4275 $Y=135225 $D=87
D2 GNDA 6 p_nwd AREA=7338.63 PJ=343.3 $X=123850 $Y=119100 $D=87
D3 GNDA 7 p_nwd AREA=1888.05 PJ=175 $X=193000 $Y=211450 $D=87
D4 GNDA GNDA p_nwd AREA=17415.8 PJ=546.1 $X=239000 $Y=120500 $D=87
M5 BIAS BIAS BIAS GNDA nmos4 L=1e-05 W=5e-06 AD=4.25e-12 AS=4.25e-12 PD=6.7e-06 PS=6.7e-06 NRD=0.085 NRS=0.085 $X=203275 $Y=323775 $D=38
M6 BIAS BIAS BIAS GNDA nmos4 L=1e-05 W=5e-06 AD=4.25e-12 AS=4.25e-12 PD=6.7e-06 PS=6.7e-06 NRD=0.085 NRS=0.085 $X=203275 $Y=355025 $D=38
M7 GNDA BIAS BIAS GNDA nmos4 L=1e-05 W=5e-06 AD=4.25e-12 AS=4.25e-12 PD=6.7e-06 PS=6.7e-06 NRD=0.085 NRS=0.085 $X=203275 $Y=330025 $D=37
M8 GNDA BIAS 5 GNDA nmos4 L=1e-05 W=5e-06 AD=4.25e-12 AS=4.25e-12 PD=6.7e-06 PS=6.7e-06 NRD=0.085 NRS=0.085 $X=203275 $Y=336275 $D=37
M9 GNDA BIAS BIAS GNDA nmos4 L=1e-05 W=5e-06 AD=4.25e-12 AS=4.25e-12 PD=6.7e-06 PS=6.7e-06 NRD=0.085 NRS=0.085 $X=203275 $Y=342525 $D=37
M10 GNDA BIAS 5 GNDA nmos4 L=1e-05 W=5e-06 AD=4.25e-12 AS=4.25e-12 PD=6.7e-06 PS=6.7e-06 NRD=0.085 NRS=0.085 $X=203275 $Y=348775 $D=37
M11 14 10 GNDA GNDA nmos4 L=1e-06 W=5e-06 AD=2.5e-12 AS=4.25e-12 PD=1e-06 PS=6.7e-06 NRD=0.085 NRS=0.085 $X=219775 $Y=173375 $D=37
M12 BG_REF 11 14 GNDA nmos4 L=1e-05 W=5e-06 AD=4.25e-12 AS=4.25e-12 PD=6.7e-06 PS=6.7e-06 NRD=0.085 NRS=0.085 $X=220000 $Y=190850 $D=37
M13 GNDA 10 14 GNDA nmos4 L=1e-06 W=5e-06 AD=4.25e-12 AS=2.5e-12 PD=6.7e-06 PS=1e-06 NRD=0.085 NRS=0.085 $X=221775 $Y=173375 $D=37
M14 8 8 GNDA GNDA nmos4 L=1e-05 W=5e-07 AD=5.9e-13 AS=5.9e-13 PD=2.7e-06 PS=2.7e-06 NRD=0.85 NRS=0.85 $X=236350 $Y=232050 $D=37
M15 VDDA VDDA VDDA VDDA pmos4 L=1e-05 W=5e-06 AD=4.25e-12 AS=4.25e-12 PD=6.7e-06 PS=6.7e-06 NRD=0.085 NRS=0.085 $X=42725 $Y=219700 $D=42
M16 VDDA VDDA VDDA VDDA pmos4 L=1e-05 W=5e-06 AD=4.25e-12 AS=4.25e-12 PD=6.7e-06 PS=6.7e-06 NRD=0.085 NRS=0.085 $X=42725 $Y=347800 $D=42
M17 VDDA VDDA VDDA VDDA pmos4 L=1e-05 W=5e-06 AD=4.25e-12 AS=4.25e-12 PD=6.7e-06 PS=6.7e-06 NRD=0.085 NRS=0.085 $X=55025 $Y=219700 $D=42
M18 VDDA VDDA VDDA VDDA pmos4 L=1e-05 W=5e-06 AD=4.25e-12 AS=4.25e-12 PD=6.7e-06 PS=6.7e-06 NRD=0.085 NRS=0.085 $X=55025 $Y=347800 $D=42
M19 VDDA VDDA VDDA VDDA pmos4 L=1e-05 W=5e-06 AD=4.25e-12 AS=4.25e-12 PD=6.7e-06 PS=6.7e-06 NRD=0.085 NRS=0.085 $X=67325 $Y=219700 $D=42
M20 VDDA VDDA VDDA VDDA pmos4 L=1e-05 W=5e-06 AD=4.25e-12 AS=4.25e-12 PD=6.7e-06 PS=6.7e-06 NRD=0.085 NRS=0.085 $X=67325 $Y=347800 $D=42
M21 VDDA VDDA VDDA VDDA pmos4 L=1e-05 W=5e-06 AD=4.25e-12 AS=4.25e-12 PD=6.7e-06 PS=6.7e-06 NRD=0.085 NRS=0.085 $X=79625 $Y=219700 $D=42
M22 VDDA VDDA VDDA VDDA pmos4 L=1e-05 W=5e-06 AD=4.25e-12 AS=4.25e-12 PD=6.7e-06 PS=6.7e-06 NRD=0.085 NRS=0.085 $X=79625 $Y=347800 $D=42
M23 VDDA VDDA VDDA VDDA pmos4 L=1e-05 W=5e-06 AD=4.25e-12 AS=4.25e-12 PD=6.7e-06 PS=6.7e-06 NRD=0.085 NRS=0.085 $X=91925 $Y=219700 $D=42
M24 VDDA VDDA VDDA VDDA pmos4 L=1e-05 W=5e-06 AD=4.25e-12 AS=4.25e-12 PD=6.7e-06 PS=6.7e-06 NRD=0.085 NRS=0.085 $X=91925 $Y=347800 $D=42
M25 VDDA VDDA VDDA VDDA pmos4 L=1e-05 W=5e-06 AD=4.25e-12 AS=4.25e-12 PD=6.7e-06 PS=6.7e-06 NRD=0.085 NRS=0.085 $X=104225 $Y=219700 $D=42
M26 VDDA VDDA VDDA VDDA pmos4 L=1e-05 W=5e-06 AD=4.25e-12 AS=4.25e-12 PD=6.7e-06 PS=6.7e-06 NRD=0.085 NRS=0.085 $X=104225 $Y=347800 $D=42
M27 VDDA VDDA VDDA VDDA pmos4 L=1e-05 W=5e-06 AD=4.25e-12 AS=4.25e-12 PD=6.7e-06 PS=6.7e-06 NRD=0.085 NRS=0.085 $X=116525 $Y=219700 $D=42
M28 VDDA VDDA VDDA VDDA pmos4 L=1e-05 W=5e-06 AD=4.25e-12 AS=4.25e-12 PD=6.7e-06 PS=6.7e-06 NRD=0.085 NRS=0.085 $X=116525 $Y=347800 $D=42
M29 VDDA VDDA VDDA VDDA pmos4 L=1e-05 W=5e-06 AD=4.25e-12 AS=4.25e-12 PD=6.7e-06 PS=6.7e-06 NRD=0.085 NRS=0.085 $X=128825 $Y=219700 $D=42
M30 VDDA VDDA VDDA VDDA pmos4 L=1e-05 W=5e-06 AD=4.25e-12 AS=4.25e-12 PD=6.7e-06 PS=6.7e-06 NRD=0.085 NRS=0.085 $X=128825 $Y=347800 $D=42
M31 6 6 6 6 pmos4 L=4e-06 W=2.5e-05 AD=2.125e-11 AS=2.125e-11 PD=2.67e-05 PS=2.67e-05 NRD=0.017 NRS=0.017 $X=139025 $Y=130450 $D=42
M32 6 6 6 6 pmos4 L=4e-06 W=2.5e-05 AD=2.125e-11 AS=2.125e-11 PD=2.67e-05 PS=2.67e-05 NRD=0.017 NRS=0.017 $X=139025 $Y=163350 $D=42
M33 VDDA VDDA VDDA VDDA pmos4 L=1e-05 W=5e-06 AD=4.25e-12 AS=4.25e-12 PD=6.7e-06 PS=6.7e-06 NRD=0.085 NRS=0.085 $X=141125 $Y=219700 $D=42
M34 VDDA VDDA VDDA VDDA pmos4 L=1e-05 W=5e-06 AD=4.25e-12 AS=4.25e-12 PD=6.7e-06 PS=6.7e-06 NRD=0.085 NRS=0.085 $X=141125 $Y=347800 $D=42
M35 6 6 6 6 pmos4 L=4e-06 W=2.5e-05 AD=2.125e-11 AS=2.125e-11 PD=2.67e-05 PS=2.67e-05 NRD=0.017 NRS=0.017 $X=195725 $Y=130450 $D=42
M36 6 6 6 6 pmos4 L=4e-06 W=2.5e-05 AD=2.125e-11 AS=2.125e-11 PD=2.67e-05 PS=2.67e-05 NRD=0.017 NRS=0.017 $X=195725 $Y=163350 $D=42
M37 7 7 7 7 pmos4 L=3.5e-07 W=1e-05 AD=8.5e-12 AS=8.5e-12 PD=1.17e-05 PS=1.17e-05 NRD=0.0425 NRS=0.0425 $X=208175 $Y=222800 $D=42
M38 7 7 7 7 pmos4 L=3.5e-07 W=1e-05 AD=8.5e-12 AS=8.5e-12 PD=1.17e-05 PS=1.17e-05 NRD=0.0425 NRS=0.0425 $X=208175 $Y=238950 $D=42
M39 7 7 7 7 pmos4 L=3.5e-07 W=1e-05 AD=8.5e-12 AS=8.5e-12 PD=1.17e-05 PS=1.17e-05 NRD=0.0425 NRS=0.0425 $X=216125 $Y=222800 $D=42
M40 7 7 7 7 pmos4 L=3.5e-07 W=1e-05 AD=8.5e-12 AS=8.5e-12 PD=1.17e-05 PS=1.17e-05 NRD=0.0425 NRS=0.0425 $X=216125 $Y=238950 $D=42
M41 VDDA 5 BG_REF VDDA pmos4 L=1e-05 W=5e-06 AD=4.25e-12 AS=4.25e-12 PD=6.7e-06 PS=6.7e-06 NRD=0.085 NRS=0.085 $X=42725 $Y=238000 $D=41
M42 VDDA 5 BG_REF VDDA pmos4 L=1e-05 W=5e-06 AD=4.25e-12 AS=4.25e-12 PD=6.7e-06 PS=6.7e-06 NRD=0.085 NRS=0.085 $X=42725 $Y=256300 $D=41
M43 VDDA 5 BG_REF VDDA pmos4 L=1e-05 W=5e-06 AD=4.25e-12 AS=4.25e-12 PD=6.7e-06 PS=6.7e-06 NRD=0.085 NRS=0.085 $X=42725 $Y=274600 $D=41
M44 VDDA 5 BG_REF VDDA pmos4 L=1e-05 W=5e-06 AD=4.25e-12 AS=4.25e-12 PD=6.7e-06 PS=6.7e-06 NRD=0.085 NRS=0.085 $X=42725 $Y=292900 $D=41
M45 VDDA 5 BG_REF VDDA pmos4 L=1e-05 W=5e-06 AD=4.25e-12 AS=4.25e-12 PD=6.7e-06 PS=6.7e-06 NRD=0.085 NRS=0.085 $X=42725 $Y=311200 $D=41
M46 VDDA 5 BG_REF VDDA pmos4 L=1e-05 W=5e-06 AD=4.25e-12 AS=4.25e-12 PD=6.7e-06 PS=6.7e-06 NRD=0.085 NRS=0.085 $X=42725 $Y=329500 $D=41
M47 VDDA 5 BG_REF VDDA pmos4 L=1e-05 W=5e-06 AD=4.25e-12 AS=4.25e-12 PD=6.7e-06 PS=6.7e-06 NRD=0.085 NRS=0.085 $X=55025 $Y=238000 $D=41
M48 VDDA 5 6 VDDA pmos4 L=1e-05 W=5e-06 AD=4.25e-12 AS=4.25e-12 PD=6.7e-06 PS=6.7e-06 NRD=0.085 NRS=0.085 $X=55025 $Y=256300 $D=41
M49 VDDA 5 BG_REF VDDA pmos4 L=1e-05 W=5e-06 AD=4.25e-12 AS=4.25e-12 PD=6.7e-06 PS=6.7e-06 NRD=0.085 NRS=0.085 $X=55025 $Y=274600 $D=41
M50 VDDA 5 BG_REF VDDA pmos4 L=1e-05 W=5e-06 AD=4.25e-12 AS=4.25e-12 PD=6.7e-06 PS=6.7e-06 NRD=0.085 NRS=0.085 $X=55025 $Y=292900 $D=41
M51 VDDA 5 6 VDDA pmos4 L=1e-05 W=5e-06 AD=4.25e-12 AS=4.25e-12 PD=6.7e-06 PS=6.7e-06 NRD=0.085 NRS=0.085 $X=55025 $Y=311200 $D=41
M52 VDDA 5 BG_REF VDDA pmos4 L=1e-05 W=5e-06 AD=4.25e-12 AS=4.25e-12 PD=6.7e-06 PS=6.7e-06 NRD=0.085 NRS=0.085 $X=55025 $Y=329500 $D=41
M53 VDDA 5 BG_REF VDDA pmos4 L=1e-05 W=5e-06 AD=4.25e-12 AS=4.25e-12 PD=6.7e-06 PS=6.7e-06 NRD=0.085 NRS=0.085 $X=67325 $Y=238000 $D=41
M54 VDDA 5 6 VDDA pmos4 L=1e-05 W=5e-06 AD=4.25e-12 AS=4.25e-12 PD=6.7e-06 PS=6.7e-06 NRD=0.085 NRS=0.085 $X=67325 $Y=256300 $D=41
M55 VDDA 5 6 VDDA pmos4 L=1e-05 W=5e-06 AD=4.25e-12 AS=4.25e-12 PD=6.7e-06 PS=6.7e-06 NRD=0.085 NRS=0.085 $X=67325 $Y=274600 $D=41
M56 VDDA 5 6 VDDA pmos4 L=1e-05 W=5e-06 AD=4.25e-12 AS=4.25e-12 PD=6.7e-06 PS=6.7e-06 NRD=0.085 NRS=0.085 $X=67325 $Y=292900 $D=41
M57 VDDA 5 6 VDDA pmos4 L=1e-05 W=5e-06 AD=4.25e-12 AS=4.25e-12 PD=6.7e-06 PS=6.7e-06 NRD=0.085 NRS=0.085 $X=67325 $Y=311200 $D=41
M58 VDDA 5 BG_REF VDDA pmos4 L=1e-05 W=5e-06 AD=4.25e-12 AS=4.25e-12 PD=6.7e-06 PS=6.7e-06 NRD=0.085 NRS=0.085 $X=67325 $Y=329500 $D=41
M59 VDDA 5 BG_REF VDDA pmos4 L=1e-05 W=5e-06 AD=4.25e-12 AS=4.25e-12 PD=6.7e-06 PS=6.7e-06 NRD=0.085 NRS=0.085 $X=79625 $Y=238000 $D=41
M60 VDDA 5 6 VDDA pmos4 L=1e-05 W=5e-06 AD=4.25e-12 AS=4.25e-12 PD=6.7e-06 PS=6.7e-06 NRD=0.085 NRS=0.085 $X=79625 $Y=256300 $D=41
M61 VDDA 5 5 VDDA pmos4 L=1e-05 W=5e-06 AD=4.25e-12 AS=4.25e-12 PD=6.7e-06 PS=6.7e-06 NRD=0.085 NRS=0.085 $X=79625 $Y=274600 $D=41
M62 VDDA 5 6 VDDA pmos4 L=1e-05 W=5e-06 AD=4.25e-12 AS=4.25e-12 PD=6.7e-06 PS=6.7e-06 NRD=0.085 NRS=0.085 $X=79625 $Y=292900 $D=41
M63 VDDA 5 6 VDDA pmos4 L=1e-05 W=5e-06 AD=4.25e-12 AS=4.25e-12 PD=6.7e-06 PS=6.7e-06 NRD=0.085 NRS=0.085 $X=79625 $Y=311200 $D=41
M64 VDDA 5 BG_REF VDDA pmos4 L=1e-05 W=5e-06 AD=4.25e-12 AS=4.25e-12 PD=6.7e-06 PS=6.7e-06 NRD=0.085 NRS=0.085 $X=79625 $Y=329500 $D=41
M65 VDDA 5 BG_REF VDDA pmos4 L=1e-05 W=5e-06 AD=4.25e-12 AS=4.25e-12 PD=6.7e-06 PS=6.7e-06 NRD=0.085 NRS=0.085 $X=91925 $Y=238000 $D=41
M66 VDDA 5 6 VDDA pmos4 L=1e-05 W=5e-06 AD=4.25e-12 AS=4.25e-12 PD=6.7e-06 PS=6.7e-06 NRD=0.085 NRS=0.085 $X=91925 $Y=256300 $D=41
M67 VDDA 5 8 VDDA pmos4 L=1e-05 W=5e-06 AD=4.25e-12 AS=4.25e-12 PD=6.7e-06 PS=6.7e-06 NRD=0.085 NRS=0.085 $X=91925 $Y=274600 $D=41
M68 VDDA 5 7 VDDA pmos4 L=1e-05 W=5e-06 AD=4.25e-12 AS=4.25e-12 PD=6.7e-06 PS=6.7e-06 NRD=0.085 NRS=0.085 $X=91925 $Y=292900 $D=41
M69 VDDA 5 6 VDDA pmos4 L=1e-05 W=5e-06 AD=4.25e-12 AS=4.25e-12 PD=6.7e-06 PS=6.7e-06 NRD=0.085 NRS=0.085 $X=91925 $Y=311200 $D=41
M70 VDDA 5 BG_REF VDDA pmos4 L=1e-05 W=5e-06 AD=4.25e-12 AS=4.25e-12 PD=6.7e-06 PS=6.7e-06 NRD=0.085 NRS=0.085 $X=91925 $Y=329500 $D=41
M71 VDDA 5 BG_REF VDDA pmos4 L=1e-05 W=5e-06 AD=4.25e-12 AS=4.25e-12 PD=6.7e-06 PS=6.7e-06 NRD=0.085 NRS=0.085 $X=104225 $Y=238000 $D=41
M72 VDDA 5 6 VDDA pmos4 L=1e-05 W=5e-06 AD=4.25e-12 AS=4.25e-12 PD=6.7e-06 PS=6.7e-06 NRD=0.085 NRS=0.085 $X=104225 $Y=256300 $D=41
M73 VDDA 5 6 VDDA pmos4 L=1e-05 W=5e-06 AD=4.25e-12 AS=4.25e-12 PD=6.7e-06 PS=6.7e-06 NRD=0.085 NRS=0.085 $X=104225 $Y=274600 $D=41
M74 VDDA 5 5 VDDA pmos4 L=1e-05 W=5e-06 AD=4.25e-12 AS=4.25e-12 PD=6.7e-06 PS=6.7e-06 NRD=0.085 NRS=0.085 $X=104225 $Y=292900 $D=41
M75 VDDA 5 6 VDDA pmos4 L=1e-05 W=5e-06 AD=4.25e-12 AS=4.25e-12 PD=6.7e-06 PS=6.7e-06 NRD=0.085 NRS=0.085 $X=104225 $Y=311200 $D=41
M76 VDDA 5 BG_REF VDDA pmos4 L=1e-05 W=5e-06 AD=4.25e-12 AS=4.25e-12 PD=6.7e-06 PS=6.7e-06 NRD=0.085 NRS=0.085 $X=104225 $Y=329500 $D=41
M77 VDDA 5 BG_REF VDDA pmos4 L=1e-05 W=5e-06 AD=4.25e-12 AS=4.25e-12 PD=6.7e-06 PS=6.7e-06 NRD=0.085 NRS=0.085 $X=116525 $Y=238000 $D=41
M78 VDDA 5 6 VDDA pmos4 L=1e-05 W=5e-06 AD=4.25e-12 AS=4.25e-12 PD=6.7e-06 PS=6.7e-06 NRD=0.085 NRS=0.085 $X=116525 $Y=256300 $D=41
M79 VDDA 5 6 VDDA pmos4 L=1e-05 W=5e-06 AD=4.25e-12 AS=4.25e-12 PD=6.7e-06 PS=6.7e-06 NRD=0.085 NRS=0.085 $X=116525 $Y=274600 $D=41
M80 VDDA 5 6 VDDA pmos4 L=1e-05 W=5e-06 AD=4.25e-12 AS=4.25e-12 PD=6.7e-06 PS=6.7e-06 NRD=0.085 NRS=0.085 $X=116525 $Y=292900 $D=41
M81 VDDA 5 6 VDDA pmos4 L=1e-05 W=5e-06 AD=4.25e-12 AS=4.25e-12 PD=6.7e-06 PS=6.7e-06 NRD=0.085 NRS=0.085 $X=116525 $Y=311200 $D=41
M82 VDDA 5 BG_REF VDDA pmos4 L=1e-05 W=5e-06 AD=4.25e-12 AS=4.25e-12 PD=6.7e-06 PS=6.7e-06 NRD=0.085 NRS=0.085 $X=116525 $Y=329500 $D=41
M83 VDDA 5 BG_REF VDDA pmos4 L=1e-05 W=5e-06 AD=4.25e-12 AS=4.25e-12 PD=6.7e-06 PS=6.7e-06 NRD=0.085 NRS=0.085 $X=128825 $Y=238000 $D=41
M84 VDDA 5 6 VDDA pmos4 L=1e-05 W=5e-06 AD=4.25e-12 AS=4.25e-12 PD=6.7e-06 PS=6.7e-06 NRD=0.085 NRS=0.085 $X=128825 $Y=256300 $D=41
M85 VDDA 5 BG_REF VDDA pmos4 L=1e-05 W=5e-06 AD=4.25e-12 AS=4.25e-12 PD=6.7e-06 PS=6.7e-06 NRD=0.085 NRS=0.085 $X=128825 $Y=274600 $D=41
M86 VDDA 5 BG_REF VDDA pmos4 L=1e-05 W=5e-06 AD=4.25e-12 AS=4.25e-12 PD=6.7e-06 PS=6.7e-06 NRD=0.085 NRS=0.085 $X=128825 $Y=292900 $D=41
M87 VDDA 5 6 VDDA pmos4 L=1e-05 W=5e-06 AD=4.25e-12 AS=4.25e-12 PD=6.7e-06 PS=6.7e-06 NRD=0.085 NRS=0.085 $X=128825 $Y=311200 $D=41
M88 VDDA 5 BG_REF VDDA pmos4 L=1e-05 W=5e-06 AD=4.25e-12 AS=4.25e-12 PD=6.7e-06 PS=6.7e-06 NRD=0.085 NRS=0.085 $X=128825 $Y=329500 $D=41
M89 VDDA 5 BG_REF VDDA pmos4 L=1e-05 W=5e-06 AD=4.25e-12 AS=4.25e-12 PD=6.7e-06 PS=6.7e-06 NRD=0.085 NRS=0.085 $X=141125 $Y=238000 $D=41
M90 VDDA 5 BG_REF VDDA pmos4 L=1e-05 W=5e-06 AD=4.25e-12 AS=4.25e-12 PD=6.7e-06 PS=6.7e-06 NRD=0.085 NRS=0.085 $X=141125 $Y=256300 $D=41
M91 VDDA 5 BG_REF VDDA pmos4 L=1e-05 W=5e-06 AD=4.25e-12 AS=4.25e-12 PD=6.7e-06 PS=6.7e-06 NRD=0.085 NRS=0.085 $X=141125 $Y=274600 $D=41
M92 VDDA 5 BG_REF VDDA pmos4 L=1e-05 W=5e-06 AD=4.25e-12 AS=4.25e-12 PD=6.7e-06 PS=6.7e-06 NRD=0.085 NRS=0.085 $X=141125 $Y=292900 $D=41
M93 VDDA 5 BG_REF VDDA pmos4 L=1e-05 W=5e-06 AD=4.25e-12 AS=4.25e-12 PD=6.7e-06 PS=6.7e-06 NRD=0.085 NRS=0.085 $X=141125 $Y=311200 $D=41
M94 VDDA 5 BG_REF VDDA pmos4 L=1e-05 W=5e-06 AD=4.25e-12 AS=4.25e-12 PD=6.7e-06 PS=6.7e-06 NRD=0.085 NRS=0.085 $X=141125 $Y=329500 $D=41
M95 6 13 10 6 pmos4 L=4e-06 W=2.5e-05 AD=2.125e-11 AS=2.125e-11 PD=2.67e-05 PS=2.67e-05 NRD=0.017 NRS=0.017 $X=164225 $Y=130450 $D=41
M96 6 15 9 6 pmos4 L=4e-06 W=2.5e-05 AD=2.125e-11 AS=2.125e-11 PD=2.67e-05 PS=2.67e-05 NRD=0.017 NRS=0.017 $X=164225 $Y=163350 $D=41
M97 6 13 10 6 pmos4 L=4e-06 W=2.5e-05 AD=2.125e-11 AS=2.125e-11 PD=2.67e-05 PS=2.67e-05 NRD=0.017 NRS=0.017 $X=189425 $Y=130450 $D=41
M98 6 15 9 6 pmos4 L=4e-06 W=2.5e-05 AD=2.125e-11 AS=2.125e-11 PD=2.67e-05 PS=2.67e-05 NRD=0.017 NRS=0.017 $X=189425 $Y=163350 $D=41
M99 12 BG_REF 7 7 pmos4 L=3.5e-07 W=1e-05 AD=8.5e-12 AS=8.5e-12 PD=1.17e-05 PS=1.17e-05 NRD=0.0425 NRS=0.0425 $X=210825 $Y=222800 $D=41
M100 11 8 7 7 pmos4 L=3.5e-07 W=1e-05 AD=8.5e-12 AS=8.5e-12 PD=1.17e-05 PS=1.17e-05 NRD=0.0425 NRS=0.0425 $X=210825 $Y=238950 $D=41
M101 11 8 7 7 pmos4 L=3.5e-07 W=1e-05 AD=8.5e-12 AS=8.5e-12 PD=1.17e-05 PS=1.17e-05 NRD=0.0425 NRS=0.0425 $X=213475 $Y=222800 $D=41
M102 12 BG_REF 7 7 pmos4 L=3.5e-07 W=1e-05 AD=8.5e-12 AS=8.5e-12 PD=1.17e-05 PS=1.17e-05 NRD=0.0425 NRS=0.0425 $X=213475 $Y=238950 $D=41
C103 BG_REF 10 $[cpolya] $A=3466.12 $P=235.5 $X=7425 $Y=137575 $D=58
X111 GNDA 9 9 nmos4_CDNS_780038168286 $T=83875 144125 0 270 $X=83625 $Y=133725
X112 GNDA 10 9 nmos4_CDNS_780038168286 $T=83875 157525 0 270 $X=83625 $Y=147125
X113 GNDA 10 9 nmos4_CDNS_780038168286 $T=96675 144125 0 270 $X=96425 $Y=133725
X114 GNDA 9 9 nmos4_CDNS_780038168286 $T=96675 157525 0 270 $X=96425 $Y=147125
X115 GNDA 11 12 nmos4_CDNS_780038168286 $T=203625 277400 0 0 $X=203225 $Y=277150
X116 GNDA 12 12 nmos4_CDNS_780038168286 $T=203625 289700 0 0 $X=203225 $Y=289450
X117 GNDA 12 12 nmos4_CDNS_780038168286 $T=217125 277400 0 0 $X=216725 $Y=277150
X118 GNDA 11 12 nmos4_CDNS_780038168286 $T=217125 289700 0 0 $X=216725 $Y=289450
X119 GNDA GNDA vert10_4 $T=386925 249650 1 0 $X=386925 $Y=232850
X120 GNDA GNDA vert10_4 $T=386925 268350 1 0 $X=386925 $Y=251550
X121 GNDA GNDA vert10_4 $T=386925 287050 1 0 $X=386925 $Y=270250
X122 GNDA GNDA vert10_4 $T=386925 305750 1 0 $X=386925 $Y=288950
X123 GNDA GNDA vert10_4 $T=386925 324450 1 0 $X=386925 $Y=307650
X124 GNDA GNDA vert10_4 $T=386925 343150 1 0 $X=386925 $Y=326350
X125 GNDA GNDA vert10_4 $T=386925 361850 1 0 $X=386925 $Y=345050
X126 32 17 rpolyhc_CDNS_7800381682811 $T=248275 127775 0 0 $X=240525 $Y=122025
X127 29 13 rpolyhc_CDNS_7800381682811 $T=256825 146275 1 180 $X=240525 $Y=140525
X128 35 15 rpolyhc_CDNS_7800381682811 $T=248275 177775 1 0 $X=240525 $Y=159025
X129 BG_REF 16 rpolyhc_CDNS_7800381682811 $T=248275 183275 0 0 $X=240525 $Y=177525
X130 BG_REF 30 rpolyhc_CDNS_7800381682811 $T=248275 214775 1 0 $X=240525 $Y=196025
X131 17 34 rpolyhc_CDNS_7800381682811 $T=266325 146275 0 0 $X=258575 $Y=140525
X132 21 15 rpolyhc_CDNS_7800381682811 $T=274875 177775 0 180 $X=258575 $Y=159025
X133 34 35 rpolyhc_CDNS_7800381682811 $T=284375 164775 0 0 $X=276625 $Y=159025
X134 43 38 rpolyhc_CDNS_7800381682811 $T=310975 127775 1 180 $X=294675 $Y=122025
X135 GNDA GNDA rpolyhc_CDNS_7800381682811 $T=320475 127775 0 0 $X=312725 $Y=122025
X136 22 41 rpolyhc_CDNS_7800381682811 $T=329025 159275 0 180 $X=312725 $Y=140525
X137 41 43 rpolyhc_CDNS_7800381682811 $T=338525 140775 1 0 $X=330775 $Y=122025
X138 23 22 rpolyhc_CDNS_7800381682811 $T=347075 164775 1 180 $X=330775 $Y=159025
X139 42 24 rpolyhc_CDNS_7800381682811 $T=338525 183275 0 0 $X=330775 $Y=177525
X140 54 45 rpolyhc_CDNS_7800381682811 $T=365125 127775 1 180 $X=348825 $Y=122025
X141 46 47 rpolyhc_CDNS_7800381682811 $T=356575 164775 0 0 $X=348825 $Y=159025
X142 27 50 rpolyhc_CDNS_7800381682811 $T=383175 140775 0 180 $X=366875 $Y=122025
X143 52 54 rpolyhc_CDNS_7800381682811 $T=392675 140775 1 0 $X=384925 $Y=122025
X144 51 55 rpolyhc_CDNS_7800381682811 $T=392675 196275 1 0 $X=384925 $Y=177525
X145 30 18 33 19 ICV_9 $T=266325 196275 1 0 $X=258575 $Y=177525
X146 16 33 18 36 ICV_9 $T=266325 201775 0 0 $X=258575 $Y=196025
X147 36 42 39 40 ICV_9 $T=302425 196275 1 0 $X=294675 $Y=177525
X148 19 39 GNDA GNDA ICV_9 $T=302425 201775 0 0 $X=294675 $Y=196025
X149 40 44 24 48 ICV_9 $T=338525 201775 0 0 $X=330775 $Y=196025
X150 44 25 48 28 ICV_9 $T=356575 196275 1 0 $X=348825 $Y=177525
X151 25 51 28 56 ICV_9 $T=374625 201775 0 0 $X=366875 $Y=196025
X152 20 32 31 29 ICV_10 $T=274875 140775 0 180 $X=258575 $Y=122025
X153 47 20 37 31 ICV_10 $T=292925 159275 0 180 $X=276625 $Y=140525
X154 49 21 38 37 ICV_10 $T=310975 164775 1 180 $X=294675 $Y=159025
X155 50 23 45 46 ICV_10 $T=347075 146275 1 180 $X=330775 $Y=140525
X156 55 27 53 52 ICV_10 $T=383175 159275 0 180 $X=366875 $Y=140525
X157 56 53 26 49 ICV_10 $T=383175 177775 0 180 $X=366875 $Y=159025
X158 GNDA GNDA GNDA GNDA GNDA ICV_12 $T=251725 249650 1 0 $X=251725 $Y=232850
X159 GNDA GNDA 26 26 26 ICV_12 $T=251725 268350 1 0 $X=251725 $Y=251550
X160 GNDA GNDA 26 26 26 ICV_12 $T=251725 287050 1 0 $X=251725 $Y=270250
X161 GNDA GNDA 26 26 26 ICV_12 $T=251725 305750 1 0 $X=251725 $Y=288950
X162 GNDA GNDA 26 26 GNDA ICV_12 $T=251725 324450 1 0 $X=251725 $Y=307650
X163 GNDA GNDA 26 26 26 ICV_12 $T=251725 343150 1 0 $X=251725 $Y=326350
X164 GNDA GNDA GNDA GNDA GNDA ICV_12 $T=251725 361850 1 0 $X=251725 $Y=345050
X165 GNDA GNDA GNDA GNDA GNDA ICV_12 $T=319325 249650 1 0 $X=319325 $Y=232850
X166 GNDA GNDA 26 26 26 ICV_12 $T=319325 268350 1 0 $X=319325 $Y=251550
X167 26 GNDA 26 26 26 ICV_12 $T=319325 287050 1 0 $X=319325 $Y=270250
X168 13 GNDA 26 26 26 ICV_12 $T=319325 305750 1 0 $X=319325 $Y=288950
X169 26 GNDA GNDA 26 26 ICV_12 $T=319325 324450 1 0 $X=319325 $Y=307650
X170 26 GNDA 26 26 26 ICV_12 $T=319325 343150 1 0 $X=319325 $Y=326350
X171 GNDA GNDA GNDA GNDA GNDA ICV_12 $T=319325 361850 1 0 $X=319325 $Y=345050
X205 6 9 10 15 13 ICV_14 $T=143875 155450 1 270 $X=136975 $Y=129250
X206 6 10 9 13 15 ICV_14 $T=143875 188350 1 270 $X=136975 $Y=162150
X207 6 9 10 15 13 ICV_14 $T=169075 155450 1 270 $X=162175 $Y=129250
X208 6 10 9 13 15 ICV_14 $T=169075 188350 1 270 $X=162175 $Y=162150
X303 VDDA ICV_17 $T=41275 219700 0 90 $X=28375 $Y=218500
X304 VDDA ICV_17 $T=41275 238000 0 90 $X=28375 $Y=236800
X305 VDDA ICV_17 $T=41275 256300 0 90 $X=28375 $Y=255100
X306 VDDA ICV_17 $T=41275 274600 0 90 $X=28375 $Y=273400
X307 VDDA ICV_17 $T=41275 292900 0 90 $X=28375 $Y=291700
X308 VDDA ICV_17 $T=41275 311200 0 90 $X=28375 $Y=310000
X309 VDDA ICV_17 $T=41275 329500 0 90 $X=28375 $Y=328300
X310 VDDA ICV_17 $T=41275 347800 0 90 $X=28375 $Y=346600
.ENDS
***************************************
.SUBCKT pmos4_CDNS_7800381682825
** N=5 EP=0 IP=0 FDC=0
.ENDS
***************************************
.SUBCKT cvar_CDNS_7800381682827 1 2 3
** N=3 EP=3 IP=0 FDC=2
M0 2 1 2 3 cvar w=0.00099 l=6.5e-07 cols=10 rows=15 $X=0 $Y=0 $D=62
D1 3 2 p_nwd AREA=2171.6 PJ=279.6 $X=-300 $Y=-300 $D=87
.ENDS
***************************************
.SUBCKT ICV_18 3 4 5
** N=6 EP=3 IP=10 FDC=1
M0 4 5 3 3 pmos4 L=3e-05 W=1e-05 AD=8.5e-12 AS=8.5e-12 PD=1.17e-05 PS=1.17e-05 NRD=0.0425 NRS=0.0425 $X=11250 $Y=850 $D=41
.ENDS
***************************************
.SUBCKT pmos4_CDNS_7800381682824
** N=5 EP=0 IP=0 FDC=0
.ENDS
***************************************
.SUBCKT ICV_19 3 4 5 7
** N=7 EP=4 IP=10 FDC=1
M0 4 5 3 7 pmos4 L=2e-06 W=5e-06 AD=4.25e-12 AS=4.25e-12 PD=6.7e-06 PS=6.7e-06 NRD=0.085 NRS=0.085 $X=6250 $Y=850 $D=41
.ENDS
***************************************
.SUBCKT ICV_20 3 4 5 6 7
** N=8 EP=5 IP=12 FDC=3
M0 5 7 3 3 pmos4 L=3e-05 W=1e-05 AD=8.5e-12 AS=8.5e-12 PD=1.17e-05 PS=1.17e-05 NRD=0.0425 NRS=0.0425 $X=22500 $Y=850 $D=41
X1 3 4 7 ICV_18 $T=0 0 0 0 $X=-1200 $Y=-1200
X2 3 6 7 ICV_18 $T=22500 0 0 0 $X=21300 $Y=-1200
.ENDS
***************************************
.SUBCKT nmos4_CDNS_7800381682828
** N=4 EP=0 IP=0 FDC=0
.ENDS
***************************************
.SUBCKT ICV_21
** N=7 EP=0 IP=8 FDC=0
.ENDS
***************************************
.SUBCKT ICV_22 3 4 5 9 10 12
** N=12 EP=6 IP=14 FDC=2
M0 4 9 3 12 nmos4 L=1e-06 W=2.85e-05 AD=2.4225e-11 AS=2.4225e-11 PD=3.02e-05 PS=3.02e-05 NRD=0.0149123 NRS=0.0149123 $X=0 $Y=4150 $D=37
M1 5 10 3 12 nmos4 L=1e-06 W=2.85e-05 AD=2.4225e-11 AS=2.4225e-11 PD=3.02e-05 PS=3.02e-05 NRD=0.0149123 NRS=0.0149123 $X=0 $Y=7450 $D=37
.ENDS
***************************************
.SUBCKT pmos4_CDNS_7800381682829
** N=5 EP=0 IP=0 FDC=0
.ENDS
***************************************
.SUBCKT ICV_23
** N=7 EP=0 IP=10 FDC=0
.ENDS
***************************************
.SUBCKT fbias_cur_ref2_layout VDDA GNDA OUT1 OUT2 OUT3 OUT4 OUT5 OUT6 OUT7 OUT8 OUT9 OUT10 OUT11 BIAS VRES VBG
** N=34 EP=16 IP=303 FDC=109
R0 2 7 L=3.025e-05 W=8e-07 $[rpolyh] $X=75450 $Y=124575 $D=18
D1 GNDA VDDA p_nwd AREA=3702.2 PJ=258.6 $X=8300 $Y=138325 $D=87
D2 GNDA VDDA p_nwd AREA=9463.68 PJ=531.2 $X=16950 $Y=216800 $D=87
D3 GNDA VDDA p_nwd AREA=169.219 PJ=53.25 $X=8775 $Y=187975 $D=87
D4 GNDA GNDA p_nwd AREA=352.17 PJ=78.9 $X=70700 $Y=117875 $D=87
D5 GNDA VDDA p_nwd AREA=86.1 PJ=37.4 $X=98700 $Y=165375 $D=87
D6 GNDA VDDA p_nwd AREA=943.28 PJ=202.2 $X=113250 $Y=164225 $D=87
M7 BIAS BIAS BIAS GNDA nmos4 L=1e-05 W=5e-06 AD=4.25e-12 AS=4.25e-12 PD=6.7e-06 PS=6.7e-06 NRD=0.085 NRS=0.085 $X=19950 $Y=117675 $D=38
M8 GNDA GNDA GNDA GNDA nmos4 L=1e-06 W=2.85e-05 AD=2.4225e-11 AS=2.4225e-11 PD=3.02e-05 PS=3.02e-05 NRD=0.0149123 NRS=0.0149123 $X=29700 $Y=29125 $D=38
M9 GNDA GNDA GNDA GNDA nmos4 L=1e-06 W=2.85e-05 AD=2.4225e-11 AS=2.4225e-11 PD=3.02e-05 PS=3.02e-05 NRD=0.0149123 NRS=0.0149123 $X=29700 $Y=65275 $D=38
M10 BIAS BIAS BIAS GNDA nmos4 L=1e-05 W=5e-06 AD=4.25e-12 AS=4.25e-12 PD=6.7e-06 PS=6.7e-06 NRD=0.085 NRS=0.085 $X=57450 $Y=117675 $D=38
M11 GNDA GNDA GNDA GNDA nmos4 L=1e-06 W=2.85e-05 AD=2.4225e-11 AS=2.4225e-11 PD=3.02e-05 PS=3.02e-05 NRD=0.0149123 NRS=0.0149123 $X=79200 $Y=29125 $D=38
M12 GNDA GNDA GNDA GNDA nmos4 L=1e-06 W=2.85e-05 AD=2.4225e-11 AS=2.4225e-11 PD=3.02e-05 PS=3.02e-05 NRD=0.0149123 NRS=0.0149123 $X=79200 $Y=65275 $D=38
M13 GNDA BIAS 6 GNDA nmos4 L=1e-05 W=5e-06 AD=4.25e-12 AS=4.25e-12 PD=6.7e-06 PS=6.7e-06 NRD=0.085 NRS=0.085 $X=26200 $Y=117675 $D=37
M14 GNDA BIAS BIAS GNDA nmos4 L=1e-05 W=5e-06 AD=4.25e-12 AS=4.25e-12 PD=6.7e-06 PS=6.7e-06 NRD=0.085 NRS=0.085 $X=32450 $Y=117675 $D=37
M15 GNDA BIAS 1 GNDA nmos4 L=1e-05 W=5e-06 AD=4.25e-12 AS=4.25e-12 PD=6.7e-06 PS=6.7e-06 NRD=0.085 NRS=0.085 $X=38700 $Y=117675 $D=37
M16 2 VBG 6 GNDA nmos4 L=1e-06 W=2.85e-05 AD=2.4225e-11 AS=2.4225e-11 PD=3.02e-05 PS=3.02e-05 NRD=0.0149123 NRS=0.0149123 $X=39600 $Y=29125 $D=37
M17 3 VRES 6 GNDA nmos4 L=1e-06 W=2.85e-05 AD=2.4225e-11 AS=2.4225e-11 PD=3.02e-05 PS=3.02e-05 NRD=0.0149123 NRS=0.0149123 $X=39600 $Y=65275 $D=37
M18 3 VRES 6 GNDA nmos4 L=1e-06 W=2.85e-05 AD=2.4225e-11 AS=2.4225e-11 PD=3.02e-05 PS=3.02e-05 NRD=0.0149123 NRS=0.0149123 $X=42900 $Y=29125 $D=37
M19 2 VBG 6 GNDA nmos4 L=1e-06 W=2.85e-05 AD=2.4225e-11 AS=2.4225e-11 PD=3.02e-05 PS=3.02e-05 NRD=0.0149123 NRS=0.0149123 $X=42900 $Y=65275 $D=37
M20 GNDA BIAS 6 GNDA nmos4 L=1e-05 W=5e-06 AD=4.25e-12 AS=4.25e-12 PD=6.7e-06 PS=6.7e-06 NRD=0.085 NRS=0.085 $X=44950 $Y=117675 $D=37
M21 GNDA BIAS BIAS GNDA nmos4 L=1e-05 W=5e-06 AD=4.25e-12 AS=4.25e-12 PD=6.7e-06 PS=6.7e-06 NRD=0.085 NRS=0.085 $X=51200 $Y=117675 $D=37
M22 2 VBG 6 GNDA nmos4 L=1e-06 W=2.85e-05 AD=2.4225e-11 AS=2.4225e-11 PD=3.02e-05 PS=3.02e-05 NRD=0.0149123 NRS=0.0149123 $X=52800 $Y=29125 $D=37
M23 3 VRES 6 GNDA nmos4 L=1e-06 W=2.85e-05 AD=2.4225e-11 AS=2.4225e-11 PD=3.02e-05 PS=3.02e-05 NRD=0.0149123 NRS=0.0149123 $X=52800 $Y=65275 $D=37
M24 3 VRES 6 GNDA nmos4 L=1e-06 W=2.85e-05 AD=2.4225e-11 AS=2.4225e-11 PD=3.02e-05 PS=3.02e-05 NRD=0.0149123 NRS=0.0149123 $X=56100 $Y=29125 $D=37
M25 2 VBG 6 GNDA nmos4 L=1e-06 W=2.85e-05 AD=2.4225e-11 AS=2.4225e-11 PD=3.02e-05 PS=3.02e-05 NRD=0.0149123 NRS=0.0149123 $X=56100 $Y=65275 $D=37
M26 2 VBG 6 GNDA nmos4 L=1e-06 W=2.85e-05 AD=2.4225e-11 AS=2.4225e-11 PD=3.02e-05 PS=3.02e-05 NRD=0.0149123 NRS=0.0149123 $X=66000 $Y=29125 $D=37
M27 3 VRES 6 GNDA nmos4 L=1e-06 W=2.85e-05 AD=2.4225e-11 AS=2.4225e-11 PD=3.02e-05 PS=3.02e-05 NRD=0.0149123 NRS=0.0149123 $X=66000 $Y=65275 $D=37
M28 3 VRES 6 GNDA nmos4 L=1e-06 W=2.85e-05 AD=2.4225e-11 AS=2.4225e-11 PD=3.02e-05 PS=3.02e-05 NRD=0.0149123 NRS=0.0149123 $X=69300 $Y=29125 $D=37
M29 2 VBG 6 GNDA nmos4 L=1e-06 W=2.85e-05 AD=2.4225e-11 AS=2.4225e-11 PD=3.02e-05 PS=3.02e-05 NRD=0.0149123 NRS=0.0149123 $X=69300 $Y=65275 $D=37
M30 2 2 2 VDDA pmos4 L=3e-05 W=1e-05 AD=8.5e-12 AS=8.5e-12 PD=1.17e-05 PS=1.17e-05 NRD=0.0425 NRS=0.0425 $X=22300 $Y=223000 $D=42
M31 3 3 3 VDDA pmos4 L=5e-06 W=8.35e-06 AD=7.0975e-12 AS=7.0975e-12 PD=1.005e-05 PS=1.005e-05 NRD=0.0508982 NRS=0.0508982 $X=23500 $Y=149675 $D=42
M32 3 3 3 VDDA pmos4 L=5e-06 W=8.35e-06 AD=7.0975e-12 AS=7.0975e-12 PD=1.005e-05 PS=1.005e-05 NRD=0.0508982 NRS=0.0508982 $X=23500 $Y=161425 $D=42
M33 3 3 3 VDDA pmos4 L=5e-06 W=8.35e-06 AD=7.0975e-12 AS=7.0975e-12 PD=1.005e-05 PS=1.005e-05 NRD=0.0508982 NRS=0.0508982 $X=74600 $Y=149675 $D=42
M34 3 3 3 VDDA pmos4 L=5e-06 W=8.35e-06 AD=7.0975e-12 AS=7.0975e-12 PD=1.005e-05 PS=1.005e-05 NRD=0.0508982 NRS=0.0508982 $X=74600 $Y=161425 $D=42
M35 1 1 1 VDDA pmos4 L=2e-06 W=5e-06 AD=4.25e-12 AS=4.25e-12 PD=6.7e-06 PS=6.7e-06 NRD=0.085 NRS=0.085 $X=118600 $Y=168425 $D=42
M36 1 1 1 VDDA pmos4 L=2e-06 W=5e-06 AD=4.25e-12 AS=4.25e-12 PD=6.7e-06 PS=6.7e-06 NRD=0.085 NRS=0.085 $X=193600 $Y=168425 $D=42
M37 2 2 2 VDDA pmos4 L=3e-05 W=1e-05 AD=8.5e-12 AS=8.5e-12 PD=1.17e-05 PS=1.17e-05 NRD=0.0425 NRS=0.0425 $X=224800 $Y=223000 $D=42
M38 34 1 1 VDDA pmos4 L=2e-06 W=5e-06 AD=4.25e-12 AS=4.25e-12 PD=6.7e-06 PS=6.7e-06 NRD=0.085 NRS=0.085 $X=11525 $Y=191575 $D=41
M39 2 3 VDDA VDDA pmos4 L=5e-06 W=8.35e-06 AD=7.0975e-12 AS=7.0975e-12 PD=1.005e-05 PS=1.005e-05 NRD=0.0508982 NRS=0.0508982 $X=30800 $Y=149675 $D=41
M40 3 3 VDDA VDDA pmos4 L=5e-06 W=8.35e-06 AD=7.0975e-12 AS=7.0975e-12 PD=1.005e-05 PS=1.005e-05 NRD=0.0508982 NRS=0.0508982 $X=30800 $Y=161425 $D=41
M41 3 3 VDDA VDDA pmos4 L=5e-06 W=8.35e-06 AD=7.0975e-12 AS=7.0975e-12 PD=1.005e-05 PS=1.005e-05 NRD=0.0508982 NRS=0.0508982 $X=38100 $Y=149675 $D=41
M42 2 3 VDDA VDDA pmos4 L=5e-06 W=8.35e-06 AD=7.0975e-12 AS=7.0975e-12 PD=1.005e-05 PS=1.005e-05 NRD=0.0508982 NRS=0.0508982 $X=38100 $Y=161425 $D=41
M43 2 3 VDDA VDDA pmos4 L=5e-06 W=8.35e-06 AD=7.0975e-12 AS=7.0975e-12 PD=1.005e-05 PS=1.005e-05 NRD=0.0508982 NRS=0.0508982 $X=45400 $Y=149675 $D=41
M44 3 3 VDDA VDDA pmos4 L=5e-06 W=8.35e-06 AD=7.0975e-12 AS=7.0975e-12 PD=1.005e-05 PS=1.005e-05 NRD=0.0508982 NRS=0.0508982 $X=45400 $Y=161425 $D=41
M45 3 3 VDDA VDDA pmos4 L=5e-06 W=8.35e-06 AD=7.0975e-12 AS=7.0975e-12 PD=1.005e-05 PS=1.005e-05 NRD=0.0508982 NRS=0.0508982 $X=52700 $Y=149675 $D=41
M46 2 3 VDDA VDDA pmos4 L=5e-06 W=8.35e-06 AD=7.0975e-12 AS=7.0975e-12 PD=1.005e-05 PS=1.005e-05 NRD=0.0508982 NRS=0.0508982 $X=52700 $Y=161425 $D=41
M47 2 3 VDDA VDDA pmos4 L=5e-06 W=8.35e-06 AD=7.0975e-12 AS=7.0975e-12 PD=1.005e-05 PS=1.005e-05 NRD=0.0508982 NRS=0.0508982 $X=60000 $Y=149675 $D=41
M48 3 3 VDDA VDDA pmos4 L=5e-06 W=8.35e-06 AD=7.0975e-12 AS=7.0975e-12 PD=1.005e-05 PS=1.005e-05 NRD=0.0508982 NRS=0.0508982 $X=60000 $Y=161425 $D=41
M49 3 3 VDDA VDDA pmos4 L=5e-06 W=8.35e-06 AD=7.0975e-12 AS=7.0975e-12 PD=1.005e-05 PS=1.005e-05 NRD=0.0508982 NRS=0.0508982 $X=67300 $Y=149675 $D=41
M50 2 3 VDDA VDDA pmos4 L=5e-06 W=8.35e-06 AD=7.0975e-12 AS=7.0975e-12 PD=1.005e-05 PS=1.005e-05 NRD=0.0508982 NRS=0.0508982 $X=67300 $Y=161425 $D=41
M51 VDDA 2 8 VDDA pmos4 L=3e-05 W=1e-05 AD=8.5e-12 AS=8.5e-12 PD=1.17e-05 PS=1.17e-05 NRD=0.0425 NRS=0.0425 $X=67300 $Y=223000 $D=41
M52 VDDA 2 26 VDDA pmos4 L=3e-05 W=1e-05 AD=8.5e-12 AS=8.5e-12 PD=1.17e-05 PS=1.17e-05 NRD=0.0425 NRS=0.0425 $X=112300 $Y=223000 $D=41
M53 23 1 OUT2 VDDA pmos4 L=2e-06 W=5e-06 AD=4.25e-12 AS=4.25e-12 PD=6.7e-06 PS=6.7e-06 NRD=0.085 NRS=0.085 $X=131100 $Y=168425 $D=41
M54 25 1 OUT4 VDDA pmos4 L=2e-06 W=5e-06 AD=4.25e-12 AS=4.25e-12 PD=6.7e-06 PS=6.7e-06 NRD=0.085 NRS=0.085 $X=143600 $Y=168425 $D=41
M55 27 1 OUT6 VDDA pmos4 L=2e-06 W=5e-06 AD=4.25e-12 AS=4.25e-12 PD=6.7e-06 PS=6.7e-06 NRD=0.085 NRS=0.085 $X=156100 $Y=168425 $D=41
M56 VDDA 2 28 VDDA pmos4 L=3e-05 W=1e-05 AD=8.5e-12 AS=8.5e-12 PD=1.17e-05 PS=1.17e-05 NRD=0.0425 NRS=0.0425 $X=157300 $Y=223000 $D=41
M57 28 1 OUT8 VDDA pmos4 L=2e-06 W=5e-06 AD=4.25e-12 AS=4.25e-12 PD=6.7e-06 PS=6.7e-06 NRD=0.085 NRS=0.085 $X=168600 $Y=168425 $D=41
M58 30 1 OUT10 VDDA pmos4 L=2e-06 W=5e-06 AD=4.25e-12 AS=4.25e-12 PD=6.7e-06 PS=6.7e-06 NRD=0.085 NRS=0.085 $X=181100 $Y=168425 $D=41
M59 VDDA 2 8 VDDA pmos4 L=3e-05 W=1e-05 AD=8.5e-12 AS=8.5e-12 PD=1.17e-05 PS=1.17e-05 NRD=0.0425 NRS=0.0425 $X=202300 $Y=223000 $D=41
X67 VDDA 34 34 VDDA pmos4_CDNS_7800381682820 $T=11525 199475 1 0 $X=10325 $Y=195575
X68 8 VRES 1 VDDA pmos4_CDNS_7800381682820 $T=101450 170825 1 0 $X=100250 $Y=166925
X70 7 VRES GNDA cvar_CDNS_7800381682827 $T=120200 14800 1 180 $X=100375 $Y=13250
X71 7 VRES GNDA cvar_CDNS_7800381682827 $T=143350 14800 1 180 $X=123525 $Y=13250
X72 7 VRES GNDA cvar_CDNS_7800381682827 $T=166500 14800 1 180 $X=146675 $Y=13250
X73 7 VRES GNDA cvar_CDNS_7800381682827 $T=189650 14800 1 180 $X=169825 $Y=13250
X74 7 VRES GNDA cvar_CDNS_7800381682827 $T=212800 14800 1 180 $X=192975 $Y=13250
X75 7 VRES GNDA cvar_CDNS_7800381682827 $T=235950 14800 1 180 $X=216125 $Y=13250
X76 VDDA 32 2 ICV_18 $T=202300 253850 1 0 $X=201100 $Y=220950
X79 22 OUT1 1 VDDA ICV_19 $T=118600 171275 1 0 $X=117400 $Y=166375
X80 24 OUT3 1 VDDA ICV_19 $T=131100 171275 1 0 $X=129900 $Y=166375
X81 26 OUT5 1 VDDA ICV_19 $T=143600 171275 1 0 $X=142400 $Y=166375
X82 13 OUT7 1 VDDA ICV_19 $T=156100 171275 1 0 $X=154900 $Y=166375
X83 29 OUT9 1 VDDA ICV_19 $T=168600 171275 1 0 $X=167400 $Y=166375
X84 32 OUT11 1 VDDA ICV_19 $T=181100 171275 1 0 $X=179900 $Y=166375
X85 VDDA 8 22 23 2 ICV_20 $T=22300 253850 1 0 $X=21100 $Y=220950
X86 VDDA 24 25 8 2 ICV_20 $T=67300 253850 1 0 $X=66100 $Y=220950
X87 VDDA 27 8 13 2 ICV_20 $T=112300 253850 1 0 $X=111100 $Y=220950
X88 VDDA 8 29 30 2 ICV_20 $T=157300 253850 1 0 $X=156100 $Y=220950
X89 6 2 3 VBG VRES GNDA ICV_22 $T=28850 57625 0 270 $X=28600 $Y=28725
X90 6 3 2 VRES VBG GNDA ICV_22 $T=28850 93775 0 270 $X=28600 $Y=64875
X91 6 2 3 VBG VRES GNDA ICV_22 $T=42050 57625 0 270 $X=41800 $Y=28725
X92 6 3 2 VRES VBG GNDA ICV_22 $T=42050 93775 0 270 $X=41800 $Y=64875
X93 6 2 3 VBG VRES GNDA ICV_22 $T=55250 57625 0 270 $X=55000 $Y=28725
X94 6 3 2 VRES VBG GNDA ICV_22 $T=55250 93775 0 270 $X=55000 $Y=64875
X95 6 2 3 VBG VRES GNDA ICV_22 $T=68450 57625 0 270 $X=68200 $Y=28725
X96 6 3 2 VRES VBG GNDA ICV_22 $T=68450 93775 0 270 $X=68200 $Y=64875
.ENDS
***************************************
.SUBCKT PD_C_CDNS_78003816828153
** N=1 EP=0 IP=0 FDC=0
.ENDS
***************************************
.SUBCKT PD_C_CDNS_78003816828155
** N=1 EP=0 IP=0 FDC=0
.ENDS
***************************************
.SUBCKT nmos4_CDNS_7800381682832
** N=4 EP=0 IP=0 FDC=0
.ENDS
***************************************
.SUBCKT ICV_24
** N=7 EP=0 IP=8 FDC=0
.ENDS
***************************************
.SUBCKT PD_C_CDNS_78003816828154
** N=1 EP=0 IP=0 FDC=0
.ENDS
***************************************
.SUBCKT rpolyhc_CDNS_7800381682830 1 2
** N=3 EP=2 IP=0 FDC=1
R0 1 2 L=2.5e-05 W=8e-07 $[rpolyh] $X=-800 $Y=1550 $D=18
.ENDS
***************************************
.SUBCKT P1_C_CDNS_78003816828148
** N=2 EP=0 IP=0 FDC=0
.ENDS
***************************************
.SUBCKT ICV_25 1 2 3 6 7 9
** N=9 EP=6 IP=14 FDC=3
M0 2 6 1 9 nmos4 L=5e-06 W=3.3e-05 AD=2.805e-11 AS=2.805e-11 PD=3.47e-05 PS=3.47e-05 NRD=0.0128788 NRS=0.0128788 $X=0 $Y=-21050 $D=37
M1 3 7 1 9 nmos4 L=5e-06 W=3.3e-05 AD=2.805e-11 AS=2.805e-11 PD=3.47e-05 PS=3.47e-05 NRD=0.0128788 NRS=0.0128788 $X=0 $Y=-13750 $D=37
M2 2 6 1 9 nmos4 L=5e-06 W=3.3e-05 AD=2.805e-11 AS=2.805e-11 PD=3.47e-05 PS=3.47e-05 NRD=0.0128788 NRS=0.0128788 $X=0 $Y=-6450 $D=37
.ENDS
***************************************
.SUBCKT ICV_26
** N=7 EP=0 IP=10 FDC=0
.ENDS
***************************************
.SUBCKT ICV_27 3 4 5 8
** N=9 EP=4 IP=14 FDC=2
M0 4 8 3 3 pmos4 L=1e-05 W=5e-06 AD=4.25e-12 AS=4.25e-12 PD=6.7e-06 PS=6.7e-06 NRD=0.085 NRS=0.085 $X=6300 $Y=850 $D=41
M1 5 8 3 3 pmos4 L=1e-05 W=5e-06 AD=4.25e-12 AS=4.25e-12 PD=6.7e-06 PS=6.7e-06 NRD=0.085 NRS=0.085 $X=12600 $Y=850 $D=41
.ENDS
***************************************
.SUBCKT ICV_28 1 2 3 4 5 6
** N=6 EP=6 IP=18 FDC=8
M0 4 4 4 4 nmos4 L=5e-06 W=3.3e-05 AD=2.805e-11 AS=2.805e-11 PD=3.47e-05 PS=3.47e-05 NRD=0.0128788 NRS=0.0128788 $X=0 $Y=850 $D=38
M1 3 6 1 4 nmos4 L=5e-06 W=3.3e-05 AD=2.805e-11 AS=2.805e-11 PD=3.47e-05 PS=3.47e-05 NRD=0.0128788 NRS=0.0128788 $X=0 $Y=-28350 $D=37
X2 1 2 3 5 6 4 ICV_25 $T=0 -29200 0 0 $X=-400 $Y=-51350
X3 1 2 3 5 6 4 ICV_25 $T=0 0 0 0 $X=-400 $Y=-22150
.ENDS
***************************************
.SUBCKT ICV_29 1 2 3 4
** N=5 EP=4 IP=18 FDC=8
M0 1 1 1 2 pmos4 L=1e-05 W=5e-06 AD=4.25e-12 AS=4.25e-12 PD=6.7e-06 PS=6.7e-06 NRD=0.085 NRS=0.085 $X=0 $Y=850 $D=42
M1 3 1 2 2 pmos4 L=1e-05 W=5e-06 AD=4.25e-12 AS=4.25e-12 PD=6.7e-06 PS=6.7e-06 NRD=0.085 NRS=0.085 $X=18900 $Y=850 $D=41
M2 4 1 2 2 pmos4 L=1e-05 W=5e-06 AD=4.25e-12 AS=4.25e-12 PD=6.7e-06 PS=6.7e-06 NRD=0.085 NRS=0.085 $X=25200 $Y=850 $D=41
M3 3 1 2 2 pmos4 L=1e-05 W=5e-06 AD=4.25e-12 AS=4.25e-12 PD=6.7e-06 PS=6.7e-06 NRD=0.085 NRS=0.085 $X=44100 $Y=850 $D=41
X4 2 3 4 1 ICV_27 $T=0 0 0 0 $X=-1200 $Y=-1200
X5 2 3 4 1 ICV_27 $T=25200 0 0 0 $X=24000 $Y=-1200
.ENDS
***************************************
.SUBCKT fbias_vol_ref1_layout BIAS VDDA GNDA VBG V1600 V1500 V1000
** N=32 EP=7 IP=239 FDC=108
R0 8 13 L=8.995e-05 W=2e-06 $[rpolyh] $X=342050 $Y=248400 $D=18
D1 GNDA VDDA p_nwd AREA=6035.8 PJ=323.2 $X=226125 $Y=216950 $D=87
D2 GNDA GNDA p_nwd AREA=3481.19 PJ=240 $X=275800 $Y=154500 $D=87
D3 GNDA VDDA p_nwd AREA=508.68 PJ=96.2 $X=333800 $Y=206850 $D=87
D4 GNDA GNDA p_nwd AREA=638.775 PJ=101.1 $X=337400 $Y=244100 $D=87
M5 GNDA GNDA GNDA GNDA nmos4 L=5e-06 W=3.3e-05 AD=2.805e-11 AS=2.805e-11 PD=3.47e-05 PS=3.47e-05 NRD=0.0128788 NRS=0.0128788 $X=339750 $Y=60200 $D=38
M6 GNDA GNDA GNDA GNDA nmos4 L=5e-06 W=3.3e-05 AD=2.805e-11 AS=2.805e-11 PD=3.47e-05 PS=3.47e-05 NRD=0.0128788 NRS=0.0128788 $X=339750 $Y=99500 $D=38
M7 GNDA BIAS 10 GNDA nmos4 L=1e-05 W=5e-06 AD=4.25e-12 AS=4.25e-12 PD=6.7e-06 PS=6.7e-06 NRD=0.085 NRS=0.085 $X=239550 $Y=163000 $D=37
M8 GNDA BIAS BIAS GNDA nmos4 L=1e-05 W=5e-06 AD=4.25e-12 AS=4.25e-12 PD=6.7e-06 PS=6.7e-06 NRD=0.085 NRS=0.085 $X=239550 $Y=170700 $D=37
M9 GNDA BIAS BIAS GNDA nmos4 L=1e-05 W=5e-06 AD=4.25e-12 AS=4.25e-12 PD=6.7e-06 PS=6.7e-06 NRD=0.085 NRS=0.085 $X=251850 $Y=163000 $D=37
M10 GNDA BIAS 10 GNDA nmos4 L=1e-05 W=5e-06 AD=4.25e-12 AS=4.25e-12 PD=6.7e-06 PS=6.7e-06 NRD=0.085 NRS=0.085 $X=251850 $Y=170700 $D=37
M11 10 VBG 8 GNDA nmos4 L=5e-06 W=3.3e-05 AD=2.805e-11 AS=2.805e-11 PD=3.47e-05 PS=3.47e-05 NRD=0.0128788 NRS=0.0128788 $X=303250 $Y=60200 $D=37
M12 10 11 9 GNDA nmos4 L=5e-06 W=3.3e-05 AD=2.805e-11 AS=2.805e-11 PD=3.47e-05 PS=3.47e-05 NRD=0.0128788 NRS=0.0128788 $X=303250 $Y=99500 $D=37
M13 10 VBG 8 GNDA nmos4 L=5e-06 W=3.3e-05 AD=2.805e-11 AS=2.805e-11 PD=3.47e-05 PS=3.47e-05 NRD=0.0128788 NRS=0.0128788 $X=332450 $Y=60200 $D=37
M14 10 11 9 GNDA nmos4 L=5e-06 W=3.3e-05 AD=2.805e-11 AS=2.805e-11 PD=3.47e-05 PS=3.47e-05 NRD=0.0128788 NRS=0.0128788 $X=332450 $Y=99500 $D=37
M15 9 9 9 VDDA pmos4 L=1e-05 W=5e-06 AD=4.25e-12 AS=4.25e-12 PD=6.7e-06 PS=6.7e-06 NRD=0.085 NRS=0.085 $X=309775 $Y=232150 $D=42
M16 9 9 9 VDDA pmos4 L=1e-05 W=5e-06 AD=4.25e-12 AS=4.25e-12 PD=6.7e-06 PS=6.7e-06 NRD=0.085 NRS=0.085 $X=309775 $Y=250350 $D=42
M17 VDDA 9 8 VDDA pmos4 L=1e-05 W=5e-06 AD=4.25e-12 AS=4.25e-12 PD=6.7e-06 PS=6.7e-06 NRD=0.085 NRS=0.085 $X=290875 $Y=232150 $D=41
M18 9 9 VDDA VDDA pmos4 L=1e-05 W=5e-06 AD=4.25e-12 AS=4.25e-12 PD=6.7e-06 PS=6.7e-06 NRD=0.085 NRS=0.085 $X=290875 $Y=250350 $D=41
M19 VDDA 8 14 VDDA pmos4 L=2e-05 W=1e-05 AD=8.5e-12 AS=8.5e-12 PD=1.17e-05 PS=1.17e-05 NRD=0.0425 NRS=0.0425 $X=337150 $Y=213050 $D=41
X26 13 14 GNDA cvar_CDNS_7800381682827 $T=372725 42075 0 270 $X=371175 $Y=22250
X27 13 14 GNDA cvar_CDNS_7800381682827 $T=372725 65225 0 270 $X=371175 $Y=45400
X28 13 14 GNDA cvar_CDNS_7800381682827 $T=372725 88375 0 270 $X=371175 $Y=68550
X29 13 14 GNDA cvar_CDNS_7800381682827 $T=372725 111525 0 270 $X=371175 $Y=91700
X30 13 14 GNDA cvar_CDNS_7800381682827 $T=372725 134675 0 270 $X=371175 $Y=114850
X31 13 14 GNDA cvar_CDNS_7800381682827 $T=372725 157825 0 270 $X=371175 $Y=138000
X32 13 14 GNDA cvar_CDNS_7800381682827 $T=372725 180975 0 270 $X=371175 $Y=161150
X33 13 14 GNDA cvar_CDNS_7800381682827 $T=372725 204125 0 270 $X=371175 $Y=184300
X34 13 14 GNDA cvar_CDNS_7800381682827 $T=372725 227275 0 270 $X=371175 $Y=207450
X35 13 14 GNDA cvar_CDNS_7800381682827 $T=372725 250425 0 270 $X=371175 $Y=230600
X36 13 14 GNDA cvar_CDNS_7800381682827 $T=372725 273575 0 270 $X=371175 $Y=253750
X73 GNDA 16 rpolyhc_CDNS_7800381682830 $T=289000 162050 0 90 $X=277350 $Y=156050
X74 16 17 rpolyhc_CDNS_7800381682830 $T=282000 172050 1 90 $X=277350 $Y=166050
X75 17 15 rpolyhc_CDNS_7800381682830 $T=289000 182050 0 90 $X=277350 $Y=176050
X76 15 12 rpolyhc_CDNS_7800381682830 $T=282000 196050 0 270 $X=277350 $Y=186050
X77 18 24 rpolyhc_CDNS_7800381682830 $T=292300 166050 0 270 $X=287650 $Y=156050
X78 20 18 rpolyhc_CDNS_7800381682830 $T=299300 176050 1 270 $X=287650 $Y=166050
X79 19 20 rpolyhc_CDNS_7800381682830 $T=292300 186050 0 270 $X=287650 $Y=176050
X80 V1600 19 rpolyhc_CDNS_7800381682830 $T=299300 196050 1 270 $X=287650 $Y=186050
X81 11 21 rpolyhc_CDNS_7800381682830 $T=302600 162050 1 90 $X=297950 $Y=156050
X82 22 11 rpolyhc_CDNS_7800381682830 $T=309600 176050 1 270 $X=297950 $Y=166050
X83 V1500 V1600 rpolyhc_CDNS_7800381682830 $T=309600 182050 0 90 $X=297950 $Y=176050
X84 12 30 rpolyhc_CDNS_7800381682830 $T=302600 192050 1 90 $X=297950 $Y=186050
X85 28 V1000 rpolyhc_CDNS_7800381682830 $T=312900 162050 1 90 $X=308250 $Y=156050
X86 21 23 rpolyhc_CDNS_7800381682830 $T=312900 172050 1 90 $X=308250 $Y=166050
X87 V1000 22 rpolyhc_CDNS_7800381682830 $T=319900 186050 1 270 $X=308250 $Y=176050
X88 23 V1500 rpolyhc_CDNS_7800381682830 $T=319900 192050 0 90 $X=308250 $Y=186050
X89 24 26 rpolyhc_CDNS_7800381682830 $T=323200 162050 1 90 $X=318550 $Y=156050
X90 26 25 rpolyhc_CDNS_7800381682830 $T=330200 172050 0 90 $X=318550 $Y=166050
X91 25 27 rpolyhc_CDNS_7800381682830 $T=323200 182050 1 90 $X=318550 $Y=176050
X92 27 14 rpolyhc_CDNS_7800381682830 $T=330200 192050 0 90 $X=318550 $Y=186050
X93 31 28 rpolyhc_CDNS_7800381682830 $T=340500 166050 1 270 $X=328850 $Y=156050
X94 29 31 rpolyhc_CDNS_7800381682830 $T=333500 176050 0 270 $X=328850 $Y=166050
X95 32 29 rpolyhc_CDNS_7800381682830 $T=340500 186050 1 270 $X=328850 $Y=176050
X96 30 32 rpolyhc_CDNS_7800381682830 $T=333500 196050 0 270 $X=328850 $Y=186050
X101 10 9 8 11 VBG GNDA ICV_25 $T=309100 60200 0 90 $X=302150 $Y=59800
X102 10 8 9 VBG 11 GNDA ICV_25 $T=309100 99500 0 90 $X=302150 $Y=99100
X103 VDDA 9 8 9 ICV_27 $T=290875 243000 1 0 $X=289675 $Y=230100
X104 VDDA 8 9 9 ICV_27 $T=290875 249500 0 0 $X=289675 $Y=248300
X105 10 9 8 GNDA 11 VBG ICV_28 $T=250700 60200 0 90 $X=243750 $Y=59800
X106 10 8 9 GNDA VBG 11 ICV_28 $T=250700 99500 0 90 $X=243750 $Y=99100
X107 9 VDDA 9 8 ICV_29 $T=240475 243000 1 0 $X=239275 $Y=230100
X108 9 VDDA 8 9 ICV_29 $T=240475 249500 0 0 $X=239275 $Y=248300
.ENDS
***************************************
.SUBCKT fbias_bias2_f POR_L VDDA VRES OUT1 OUT2 OUT3 OUT4 OUT5 OUT6 OUT7 OUT8 OUT9 OUT10 OUT11 v1600 v1000 v1500 GNDA
** N=23 EP=18 IP=56 FDC=603
X0 VDDA GNDA V200_20 $T=23825 89875 0 90 $X=-225 $Y=89925
X1 VDDA GNDA V200_20 $T=184550 84150 1 0 $X=184600 $Y=60100
X2 VDDA GNDA V200_20 $T=184825 53650 1 0 $X=184875 $Y=29600
X3 VDDA GNDA V200_20 $T=845575 69175 0 90 $X=821525 $Y=69225
X4 VDDA GNDA V200_20 $T=1401725 69575 0 90 $X=1377675 $Y=69625
X5 GNDA 1 VDDA 19 POR_L fbias_por2_f $T=36050 91150 0 0 $X=35800 $Y=95348
X6 VDDA GNDA V500_20 $T=212550 23500 1 0 $X=212350 $Y=-600
X7 VDDA GNDA V500_20 $T=228100 330250 1 0 $X=227900 $Y=306150
X8 VDDA GNDA V500_20 $T=863100 23500 1 0 $X=862900 $Y=-600
X9 VDDA GNDA V500_20 $T=863400 330250 1 0 $X=863200 $Y=306150
X10 3 1 6 2 GNDA VDDA fbias_gm_c1_f2 $T=236850 94900 0 0 $X=241950 $Y=104198
X11 19 VDDA GNDA 6 fecg_bandgap3_layout $T=406250 -80300 0 0 $X=408525 $Y=32048
X12 VDDA GNDA OUT1 OUT2 OUT3 OUT4 OUT5 OUT6 OUT7 OUT8 OUT9 OUT10 OUT11 3 VRES 19 fbias_cur_ref2_layout $T=849150 29500 0 0 $X=847750 $Y=35223
X13 2 VDDA GNDA 19 v1600 v1500 v1000 fbias_vol_ref1_layout $T=876650 14550 0 0 $X=1096300 $Y=31173
.ENDS
***************************************
