* SPICE NETLIST
***************************************

.SUBCKT tsv80 TOP BOTTOM SUB
.ENDS
***************************************
.SUBCKT rx POS NEG
.ENDS
***************************************
.SUBCKT Q C B E S G
.ENDS
***************************************
.SUBCKT lddn D G S B
.ENDS
***************************************
.SUBCKT phd POS NEG P
.ENDS
***************************************
.SUBCKT sbd A C SUB
.ENDS
***************************************
.SUBCKT esddlv2 A C
.ENDS
***************************************
.SUBCKT esddlv A C SUB
.ENDS
***************************************
.SUBCKT lddp D G S B
.ENDS
***************************************
.SUBCKT probepad pad
.ENDS
***************************************
.SUBCKT L POS NEG SUB
.ENDS
***************************************
.SUBCKT L POS NEG MID SUB
.ENDS
***************************************
.SUBCKT hall A B C D S P1 P2
.ENDS
***************************************
.SUBCKT V500_20 VDD GND
** N=2 EP=2 IP=0 FDC=1
C0 GND VDD $[cpolya] $A=9800 $P=1020 $X=2150 $Y=3100 $D=58
.ENDS
***************************************
.SUBCKT V200_20 VDD GND
** N=3 EP=2 IP=0 FDC=1
C0 GND VDD $[cpolya] $A=3790.5 $P=419.9 $X=5575 $Y=3100 $D=58
.ENDS
***************************************
.SUBCKT P1_C_CDNS_7807356271750
** N=2 EP=0 IP=0 FDC=0
.ENDS
***************************************
.SUBCKT P1_C_CDNS_7807356271762
** N=2 EP=0 IP=0 FDC=0
.ENDS
***************************************
.SUBCKT pmos4_CDNS_780735627176
** N=5 EP=0 IP=0 FDC=0
.ENDS
***************************************
.SUBCKT ICV_1
** N=6 EP=0 IP=10 FDC=0
.ENDS
***************************************
.SUBCKT ICV_2
** N=9 EP=0 IP=12 FDC=0
.ENDS
***************************************
.SUBCKT ICV_3
** N=11 EP=0 IP=18 FDC=0
.ENDS
***************************************
.SUBCKT ICV_4 1
** N=7 EP=1 IP=22 FDC=2
M0 1 1 1 1 pmos4 L=5e-06 W=5e-06 AD=4.25e-12 AS=4.25e-12 PD=6.7e-06 PS=6.7e-06 NRD=0.085 NRS=0.085 $X=0 $Y=-108650 $D=42
M1 1 1 1 1 pmos4 L=5e-06 W=5e-06 AD=4.25e-12 AS=4.25e-12 PD=6.7e-06 PS=6.7e-06 NRD=0.085 NRS=0.085 $X=0 $Y=850 $D=42
.ENDS
***************************************
.SUBCKT P1_C_CDNS_7807356271768
** N=2 EP=0 IP=0 FDC=0
.ENDS
***************************************
.SUBCKT nmos4_CDNS_780735627175 1 2 3
** N=3 EP=3 IP=0 FDC=1
M0 2 3 1 1 nmos4 L=1e-05 W=2e-05 AD=1.7e-11 AS=1.7e-11 PD=2.17e-05 PS=2.17e-05 NRD=0.02125 NRS=0.02125 $X=0 $Y=850 $D=37
.ENDS
***************************************
.SUBCKT P1_C_CDNS_7807356271771
** N=2 EP=0 IP=0 FDC=0
.ENDS
***************************************
.SUBCKT nmos4_CDNS_780735627174 1 2 3
** N=3 EP=3 IP=0 FDC=1
M0 2 3 1 1 nmos4 L=4e-06 W=1e-05 AD=8.5e-12 AS=8.5e-12 PD=1.17e-05 PS=1.17e-05 NRD=0.0425 NRS=0.0425 $X=0 $Y=850 $D=37
.ENDS
***************************************
.SUBCKT cpolyc_CDNS_780735627172 2 3
** N=3 EP=2 IP=0 FDC=1
C0 2 3 $[cpolya] $A=6942.87 $P=333.3 $X=1800 $Y=1000 $D=58
.ENDS
***************************************
.SUBCKT pmos4_CDNS_780735627177
** N=5 EP=0 IP=0 FDC=0
.ENDS
***************************************
.SUBCKT ICV_5
** N=8 EP=0 IP=10 FDC=0
.ENDS
***************************************
.SUBCKT ICV_6 3 4 5 9 10 13
** N=13 EP=6 IP=16 FDC=2
M0 4 9 3 13 pmos4 L=2e-06 W=1e-05 AD=8.5e-12 AS=8.5e-12 PD=1.17e-05 PS=1.17e-05 NRD=0.0425 NRS=0.0425 $X=0 $Y=-7750 $D=41
M1 5 10 3 13 pmos4 L=2e-06 W=1e-05 AD=8.5e-12 AS=8.5e-12 PD=1.17e-05 PS=1.17e-05 NRD=0.0425 NRS=0.0425 $X=0 $Y=-3450 $D=41
.ENDS
***************************************
.SUBCKT rpolyhc_CDNS_780735627170 1 2
** N=3 EP=2 IP=0 FDC=1
R0 1 2 L=0.00025 W=8e-07 $[rpolyh] $X=-800 $Y=1550 $D=18
.ENDS
***************************************
.SUBCKT ICV_7 1 2 3
*.CALIBRE ICV_CELL 9
** N=4 EP=3 IP=6 FDC=2
X0 1 2 rpolyhc_CDNS_780735627170 $T=0 0 0 0 $X=-6000 $Y=-4650
X1 2 3 rpolyhc_CDNS_780735627170 $T=49000 10300 1 180 $X=-6000 $Y=5650
.ENDS
***************************************
.SUBCKT ICV_8 1 2 3 4 5 6
** N=7 EP=6 IP=26 FDC=8
M0 4 4 4 4 pmos4 L=2e-06 W=1e-05 AD=8.5e-12 AS=8.5e-12 PD=1.17e-05 PS=1.17e-05 NRD=0.0425 NRS=0.0425 $X=0 $Y=850 $D=42
M1 2 5 1 4 pmos4 L=2e-06 W=1e-05 AD=8.5e-12 AS=8.5e-12 PD=1.17e-05 PS=1.17e-05 NRD=0.0425 NRS=0.0425 $X=0 $Y=-29250 $D=41
M2 2 5 1 4 pmos4 L=2e-06 W=1e-05 AD=8.5e-12 AS=8.5e-12 PD=1.17e-05 PS=1.17e-05 NRD=0.0425 NRS=0.0425 $X=0 $Y=-16350 $D=41
M3 3 6 1 4 pmos4 L=2e-06 W=1e-05 AD=8.5e-12 AS=8.5e-12 PD=1.17e-05 PS=1.17e-05 NRD=0.0425 NRS=0.0425 $X=0 $Y=-12050 $D=41
X4 1 3 3 6 6 4 ICV_6 $T=0 -17200 0 0 $X=-1200 $Y=-31300
X5 1 2 3 5 6 4 ICV_6 $T=0 0 0 0 $X=-1200 $Y=-14100
.ENDS
***************************************
.SUBCKT BUFFER VDDA VOUT VIN CBUF IBIAS GNDA
** N=18 EP=6 IP=250 FDC=215
R0 2 4 L=5.9e-06 W=1.2e-06 $[rpolyh] $X=159175 $Y=120350 $D=18
D1 GNDA GNDA p_nwd AREA=7231.65 PJ=371.6 $X=15875 $Y=79950 $D=87
D2 GNDA VDDA p_nwd AREA=4503.05 PJ=272.4 $X=53300 $Y=20450 $D=87
D3 GNDA GNDA p_nwd AREA=557.75 PJ=94.5 $X=147475 $Y=110700 $D=87
D4 GNDA VDDA p_nwd AREA=26054.2 PJ=646.6 $X=201525 $Y=54700 $D=87
M5 VOUT 2 GNDA GNDA nmos4 L=3.5e-07 W=5e-06 AD=2.5e-12 AS=4.25e-12 PD=1e-06 PS=6.7e-06 NRD=0.085 NRS=0.085 $X=157475 $Y=80525 $D=37
M6 GNDA 2 VOUT GNDA nmos4 L=3.5e-07 W=5e-06 AD=2.5e-12 AS=2.5e-12 PD=1e-06 PS=1e-06 NRD=0.085 NRS=0.085 $X=158825 $Y=80525 $D=37
M7 VOUT 2 GNDA GNDA nmos4 L=3.5e-07 W=5e-06 AD=2.5e-12 AS=2.5e-12 PD=1e-06 PS=1e-06 NRD=0.085 NRS=0.085 $X=160175 $Y=80525 $D=37
M8 GNDA 2 VOUT GNDA nmos4 L=3.5e-07 W=5e-06 AD=2.5e-12 AS=2.5e-12 PD=1e-06 PS=1e-06 NRD=0.085 NRS=0.085 $X=161525 $Y=80525 $D=37
M9 VOUT 2 GNDA GNDA nmos4 L=3.5e-07 W=5e-06 AD=2.5e-12 AS=2.5e-12 PD=1e-06 PS=1e-06 NRD=0.085 NRS=0.085 $X=162875 $Y=80525 $D=37
M10 GNDA 2 VOUT GNDA nmos4 L=3.5e-07 W=5e-06 AD=2.5e-12 AS=2.5e-12 PD=1e-06 PS=1e-06 NRD=0.085 NRS=0.085 $X=164225 $Y=80525 $D=37
M11 VOUT 2 GNDA GNDA nmos4 L=3.5e-07 W=5e-06 AD=2.5e-12 AS=2.5e-12 PD=1e-06 PS=1e-06 NRD=0.085 NRS=0.085 $X=165575 $Y=80525 $D=37
M12 GNDA 2 VOUT GNDA nmos4 L=3.5e-07 W=5e-06 AD=2.5e-12 AS=2.5e-12 PD=1e-06 PS=1e-06 NRD=0.085 NRS=0.085 $X=166925 $Y=80525 $D=37
M13 VOUT 2 GNDA GNDA nmos4 L=3.5e-07 W=5e-06 AD=2.5e-12 AS=2.5e-12 PD=1e-06 PS=1e-06 NRD=0.085 NRS=0.085 $X=168275 $Y=80525 $D=37
M14 GNDA 2 VOUT GNDA nmos4 L=3.5e-07 W=5e-06 AD=4.25e-12 AS=2.5e-12 PD=6.7e-06 PS=1e-06 NRD=0.085 NRS=0.085 $X=169625 $Y=80525 $D=37
M15 VDDA VDDA VDDA VDDA pmos4 L=2e-06 W=1e-05 AD=8.5e-12 AS=8.5e-12 PD=1.17e-05 PS=1.17e-05 NRD=0.0425 NRS=0.0425 $X=115800 $Y=34800 $D=42
M16 VDDA VDDA VDDA VDDA pmos4 L=2e-06 W=1e-05 AD=8.5e-12 AS=8.5e-12 PD=1.17e-05 PS=1.17e-05 NRD=0.0425 NRS=0.0425 $X=115800 $Y=52600 $D=42
M17 VDDA VDDA VDDA VDDA pmos4 L=5e-06 W=5e-06 AD=4.25e-12 AS=4.25e-12 PD=6.7e-06 PS=6.7e-06 NRD=0.085 NRS=0.085 $X=228025 $Y=73050 $D=42
M18 VDDA VDDA VDDA VDDA pmos4 L=5e-06 W=5e-06 AD=4.25e-12 AS=4.25e-12 PD=6.7e-06 PS=6.7e-06 NRD=0.085 NRS=0.085 $X=228025 $Y=201750 $D=42
M19 VDDA VDDA VDDA VDDA pmos4 L=5e-06 W=5e-06 AD=4.25e-12 AS=4.25e-12 PD=6.7e-06 PS=6.7e-06 NRD=0.085 NRS=0.085 $X=235325 $Y=73050 $D=42
M20 VDDA VDDA VDDA VDDA pmos4 L=5e-06 W=5e-06 AD=4.25e-12 AS=4.25e-12 PD=6.7e-06 PS=6.7e-06 NRD=0.085 NRS=0.085 $X=235325 $Y=201750 $D=42
M21 VDDA VDDA VDDA VDDA pmos4 L=5e-06 W=5e-06 AD=4.25e-12 AS=4.25e-12 PD=6.7e-06 PS=6.7e-06 NRD=0.085 NRS=0.085 $X=242625 $Y=73050 $D=42
M22 VDDA VDDA VDDA VDDA pmos4 L=5e-06 W=5e-06 AD=4.25e-12 AS=4.25e-12 PD=6.7e-06 PS=6.7e-06 NRD=0.085 NRS=0.085 $X=242625 $Y=201750 $D=42
M23 VDDA VDDA VDDA VDDA pmos4 L=5e-06 W=5e-06 AD=4.25e-12 AS=4.25e-12 PD=6.7e-06 PS=6.7e-06 NRD=0.085 NRS=0.085 $X=249925 $Y=73050 $D=42
M24 VDDA VDDA VDDA VDDA pmos4 L=5e-06 W=5e-06 AD=4.25e-12 AS=4.25e-12 PD=6.7e-06 PS=6.7e-06 NRD=0.085 NRS=0.085 $X=249925 $Y=201750 $D=42
M25 VDDA VDDA VDDA VDDA pmos4 L=5e-06 W=5e-06 AD=4.25e-12 AS=4.25e-12 PD=6.7e-06 PS=6.7e-06 NRD=0.085 NRS=0.085 $X=257225 $Y=73050 $D=42
M26 VDDA VDDA VDDA VDDA pmos4 L=5e-06 W=5e-06 AD=4.25e-12 AS=4.25e-12 PD=6.7e-06 PS=6.7e-06 NRD=0.085 NRS=0.085 $X=257225 $Y=201750 $D=42
M27 VDDA VDDA VDDA VDDA pmos4 L=5e-06 W=5e-06 AD=4.25e-12 AS=4.25e-12 PD=6.7e-06 PS=6.7e-06 NRD=0.085 NRS=0.085 $X=264525 $Y=73050 $D=42
M28 VDDA VDDA VDDA VDDA pmos4 L=5e-06 W=5e-06 AD=4.25e-12 AS=4.25e-12 PD=6.7e-06 PS=6.7e-06 NRD=0.085 NRS=0.085 $X=264525 $Y=201750 $D=42
M29 VDDA VDDA VDDA VDDA pmos4 L=5e-06 W=5e-06 AD=4.25e-12 AS=4.25e-12 PD=6.7e-06 PS=6.7e-06 NRD=0.085 NRS=0.085 $X=271825 $Y=73050 $D=42
M30 VDDA VDDA VDDA VDDA pmos4 L=5e-06 W=5e-06 AD=4.25e-12 AS=4.25e-12 PD=6.7e-06 PS=6.7e-06 NRD=0.085 NRS=0.085 $X=271825 $Y=201750 $D=42
M31 VDDA VDDA VDDA VDDA pmos4 L=5e-06 W=5e-06 AD=4.25e-12 AS=4.25e-12 PD=6.7e-06 PS=6.7e-06 NRD=0.085 NRS=0.085 $X=279125 $Y=73050 $D=42
M32 VDDA VDDA VDDA VDDA pmos4 L=5e-06 W=5e-06 AD=4.25e-12 AS=4.25e-12 PD=6.7e-06 PS=6.7e-06 NRD=0.085 NRS=0.085 $X=279125 $Y=201750 $D=42
M33 VDDA VDDA VDDA VDDA pmos4 L=5e-06 W=5e-06 AD=4.25e-12 AS=4.25e-12 PD=6.7e-06 PS=6.7e-06 NRD=0.085 NRS=0.085 $X=286425 $Y=73050 $D=42
M34 VDDA VDDA VDDA VDDA pmos4 L=5e-06 W=5e-06 AD=4.25e-12 AS=4.25e-12 PD=6.7e-06 PS=6.7e-06 NRD=0.085 NRS=0.085 $X=286425 $Y=201750 $D=42
M35 VDDA VDDA VDDA VDDA pmos4 L=5e-06 W=5e-06 AD=4.25e-12 AS=4.25e-12 PD=6.7e-06 PS=6.7e-06 NRD=0.085 NRS=0.085 $X=293725 $Y=73050 $D=42
M36 VDDA VDDA VDDA VDDA pmos4 L=5e-06 W=5e-06 AD=4.25e-12 AS=4.25e-12 PD=6.7e-06 PS=6.7e-06 NRD=0.085 NRS=0.085 $X=293725 $Y=201750 $D=42
M37 VDDA VDDA VDDA VDDA pmos4 L=5e-06 W=5e-06 AD=4.25e-12 AS=4.25e-12 PD=6.7e-06 PS=6.7e-06 NRD=0.085 NRS=0.085 $X=301025 $Y=73050 $D=42
M38 VDDA VDDA VDDA VDDA pmos4 L=5e-06 W=5e-06 AD=4.25e-12 AS=4.25e-12 PD=6.7e-06 PS=6.7e-06 NRD=0.085 NRS=0.085 $X=301025 $Y=201750 $D=42
M39 VDDA VDDA VDDA VDDA pmos4 L=5e-06 W=5e-06 AD=4.25e-12 AS=4.25e-12 PD=6.7e-06 PS=6.7e-06 NRD=0.085 NRS=0.085 $X=308325 $Y=73050 $D=42
M40 VDDA VDDA VDDA VDDA pmos4 L=5e-06 W=5e-06 AD=4.25e-12 AS=4.25e-12 PD=6.7e-06 PS=6.7e-06 NRD=0.085 NRS=0.085 $X=308325 $Y=201750 $D=42
M41 VDDA VDDA VDDA VDDA pmos4 L=5e-06 W=5e-06 AD=4.25e-12 AS=4.25e-12 PD=6.7e-06 PS=6.7e-06 NRD=0.085 NRS=0.085 $X=315625 $Y=73050 $D=42
M42 VDDA VDDA VDDA VDDA pmos4 L=5e-06 W=5e-06 AD=4.25e-12 AS=4.25e-12 PD=6.7e-06 PS=6.7e-06 NRD=0.085 NRS=0.085 $X=315625 $Y=201750 $D=42
M43 VDDA VDDA VDDA VDDA pmos4 L=5e-06 W=5e-06 AD=4.25e-12 AS=4.25e-12 PD=6.7e-06 PS=6.7e-06 NRD=0.085 NRS=0.085 $X=322925 $Y=73050 $D=42
M44 VDDA VDDA VDDA VDDA pmos4 L=5e-06 W=5e-06 AD=4.25e-12 AS=4.25e-12 PD=6.7e-06 PS=6.7e-06 NRD=0.085 NRS=0.085 $X=322925 $Y=201750 $D=42
M45 3 9 1 VDDA pmos4 L=2e-06 W=1e-05 AD=8.5e-12 AS=8.5e-12 PD=1.17e-05 PS=1.17e-05 NRD=0.0425 NRS=0.0425 $X=102900 $Y=34800 $D=41
M46 3 VIN 2 VDDA pmos4 L=2e-06 W=1e-05 AD=8.5e-12 AS=8.5e-12 PD=1.17e-05 PS=1.17e-05 NRD=0.0425 NRS=0.0425 $X=102900 $Y=52600 $D=41
M47 VDDA 7 VOUT VDDA pmos4 L=5e-06 W=5e-06 AD=4.25e-12 AS=4.25e-12 PD=6.7e-06 PS=6.7e-06 NRD=0.085 NRS=0.085 $X=228025 $Y=87350 $D=41
M48 VDDA 7 VOUT VDDA pmos4 L=5e-06 W=5e-06 AD=4.25e-12 AS=4.25e-12 PD=6.7e-06 PS=6.7e-06 NRD=0.085 NRS=0.085 $X=228025 $Y=101650 $D=41
M49 VDDA 7 VOUT VDDA pmos4 L=5e-06 W=5e-06 AD=4.25e-12 AS=4.25e-12 PD=6.7e-06 PS=6.7e-06 NRD=0.085 NRS=0.085 $X=228025 $Y=115950 $D=41
M50 VDDA 7 3 VDDA pmos4 L=5e-06 W=5e-06 AD=4.25e-12 AS=4.25e-12 PD=6.7e-06 PS=6.7e-06 NRD=0.085 NRS=0.085 $X=228025 $Y=130250 $D=41
M51 VDDA 7 7 VDDA pmos4 L=5e-06 W=5e-06 AD=4.25e-12 AS=4.25e-12 PD=6.7e-06 PS=6.7e-06 NRD=0.085 NRS=0.085 $X=228025 $Y=144550 $D=41
M52 VDDA 7 VOUT VDDA pmos4 L=5e-06 W=5e-06 AD=4.25e-12 AS=4.25e-12 PD=6.7e-06 PS=6.7e-06 NRD=0.085 NRS=0.085 $X=228025 $Y=158850 $D=41
M53 VDDA 7 VOUT VDDA pmos4 L=5e-06 W=5e-06 AD=4.25e-12 AS=4.25e-12 PD=6.7e-06 PS=6.7e-06 NRD=0.085 NRS=0.085 $X=228025 $Y=173150 $D=41
M54 VDDA 7 VOUT VDDA pmos4 L=5e-06 W=5e-06 AD=4.25e-12 AS=4.25e-12 PD=6.7e-06 PS=6.7e-06 NRD=0.085 NRS=0.085 $X=228025 $Y=187450 $D=41
M55 VDDA 7 VOUT VDDA pmos4 L=5e-06 W=5e-06 AD=4.25e-12 AS=4.25e-12 PD=6.7e-06 PS=6.7e-06 NRD=0.085 NRS=0.085 $X=235325 $Y=87350 $D=41
M56 VDDA 7 VOUT VDDA pmos4 L=5e-06 W=5e-06 AD=4.25e-12 AS=4.25e-12 PD=6.7e-06 PS=6.7e-06 NRD=0.085 NRS=0.085 $X=235325 $Y=101650 $D=41
M57 VDDA 7 VOUT VDDA pmos4 L=5e-06 W=5e-06 AD=4.25e-12 AS=4.25e-12 PD=6.7e-06 PS=6.7e-06 NRD=0.085 NRS=0.085 $X=235325 $Y=115950 $D=41
M58 VDDA 7 3 VDDA pmos4 L=5e-06 W=5e-06 AD=4.25e-12 AS=4.25e-12 PD=6.7e-06 PS=6.7e-06 NRD=0.085 NRS=0.085 $X=235325 $Y=130250 $D=41
M59 VDDA 7 3 VDDA pmos4 L=5e-06 W=5e-06 AD=4.25e-12 AS=4.25e-12 PD=6.7e-06 PS=6.7e-06 NRD=0.085 NRS=0.085 $X=235325 $Y=144550 $D=41
M60 VDDA 7 VOUT VDDA pmos4 L=5e-06 W=5e-06 AD=4.25e-12 AS=4.25e-12 PD=6.7e-06 PS=6.7e-06 NRD=0.085 NRS=0.085 $X=235325 $Y=158850 $D=41
M61 VDDA 7 VOUT VDDA pmos4 L=5e-06 W=5e-06 AD=4.25e-12 AS=4.25e-12 PD=6.7e-06 PS=6.7e-06 NRD=0.085 NRS=0.085 $X=235325 $Y=173150 $D=41
M62 VDDA 7 VOUT VDDA pmos4 L=5e-06 W=5e-06 AD=4.25e-12 AS=4.25e-12 PD=6.7e-06 PS=6.7e-06 NRD=0.085 NRS=0.085 $X=235325 $Y=187450 $D=41
M63 VDDA 7 VOUT VDDA pmos4 L=5e-06 W=5e-06 AD=4.25e-12 AS=4.25e-12 PD=6.7e-06 PS=6.7e-06 NRD=0.085 NRS=0.085 $X=242625 $Y=87350 $D=41
M64 VDDA 7 VOUT VDDA pmos4 L=5e-06 W=5e-06 AD=4.25e-12 AS=4.25e-12 PD=6.7e-06 PS=6.7e-06 NRD=0.085 NRS=0.085 $X=242625 $Y=101650 $D=41
M65 VDDA 7 VOUT VDDA pmos4 L=5e-06 W=5e-06 AD=4.25e-12 AS=4.25e-12 PD=6.7e-06 PS=6.7e-06 NRD=0.085 NRS=0.085 $X=242625 $Y=115950 $D=41
M66 VDDA 7 3 VDDA pmos4 L=5e-06 W=5e-06 AD=4.25e-12 AS=4.25e-12 PD=6.7e-06 PS=6.7e-06 NRD=0.085 NRS=0.085 $X=242625 $Y=130250 $D=41
M67 VDDA 7 3 VDDA pmos4 L=5e-06 W=5e-06 AD=4.25e-12 AS=4.25e-12 PD=6.7e-06 PS=6.7e-06 NRD=0.085 NRS=0.085 $X=242625 $Y=144550 $D=41
M68 VDDA 7 VOUT VDDA pmos4 L=5e-06 W=5e-06 AD=4.25e-12 AS=4.25e-12 PD=6.7e-06 PS=6.7e-06 NRD=0.085 NRS=0.085 $X=242625 $Y=158850 $D=41
M69 VDDA 7 VOUT VDDA pmos4 L=5e-06 W=5e-06 AD=4.25e-12 AS=4.25e-12 PD=6.7e-06 PS=6.7e-06 NRD=0.085 NRS=0.085 $X=242625 $Y=173150 $D=41
M70 VDDA 7 VOUT VDDA pmos4 L=5e-06 W=5e-06 AD=4.25e-12 AS=4.25e-12 PD=6.7e-06 PS=6.7e-06 NRD=0.085 NRS=0.085 $X=242625 $Y=187450 $D=41
M71 VDDA 7 VOUT VDDA pmos4 L=5e-06 W=5e-06 AD=4.25e-12 AS=4.25e-12 PD=6.7e-06 PS=6.7e-06 NRD=0.085 NRS=0.085 $X=249925 $Y=87350 $D=41
M72 VDDA 7 VOUT VDDA pmos4 L=5e-06 W=5e-06 AD=4.25e-12 AS=4.25e-12 PD=6.7e-06 PS=6.7e-06 NRD=0.085 NRS=0.085 $X=249925 $Y=101650 $D=41
M73 VDDA 7 VOUT VDDA pmos4 L=5e-06 W=5e-06 AD=4.25e-12 AS=4.25e-12 PD=6.7e-06 PS=6.7e-06 NRD=0.085 NRS=0.085 $X=249925 $Y=115950 $D=41
M74 VDDA 7 VOUT VDDA pmos4 L=5e-06 W=5e-06 AD=4.25e-12 AS=4.25e-12 PD=6.7e-06 PS=6.7e-06 NRD=0.085 NRS=0.085 $X=249925 $Y=130250 $D=41
M75 VDDA 7 VOUT VDDA pmos4 L=5e-06 W=5e-06 AD=4.25e-12 AS=4.25e-12 PD=6.7e-06 PS=6.7e-06 NRD=0.085 NRS=0.085 $X=249925 $Y=144550 $D=41
M76 VDDA 7 VOUT VDDA pmos4 L=5e-06 W=5e-06 AD=4.25e-12 AS=4.25e-12 PD=6.7e-06 PS=6.7e-06 NRD=0.085 NRS=0.085 $X=249925 $Y=158850 $D=41
M77 VDDA 7 VOUT VDDA pmos4 L=5e-06 W=5e-06 AD=4.25e-12 AS=4.25e-12 PD=6.7e-06 PS=6.7e-06 NRD=0.085 NRS=0.085 $X=249925 $Y=173150 $D=41
M78 VDDA 7 VOUT VDDA pmos4 L=5e-06 W=5e-06 AD=4.25e-12 AS=4.25e-12 PD=6.7e-06 PS=6.7e-06 NRD=0.085 NRS=0.085 $X=249925 $Y=187450 $D=41
M79 VDDA 7 VOUT VDDA pmos4 L=5e-06 W=5e-06 AD=4.25e-12 AS=4.25e-12 PD=6.7e-06 PS=6.7e-06 NRD=0.085 NRS=0.085 $X=257225 $Y=87350 $D=41
M80 VDDA 7 VOUT VDDA pmos4 L=5e-06 W=5e-06 AD=4.25e-12 AS=4.25e-12 PD=6.7e-06 PS=6.7e-06 NRD=0.085 NRS=0.085 $X=257225 $Y=101650 $D=41
M81 VDDA 7 VOUT VDDA pmos4 L=5e-06 W=5e-06 AD=4.25e-12 AS=4.25e-12 PD=6.7e-06 PS=6.7e-06 NRD=0.085 NRS=0.085 $X=257225 $Y=115950 $D=41
M82 VDDA 7 VOUT VDDA pmos4 L=5e-06 W=5e-06 AD=4.25e-12 AS=4.25e-12 PD=6.7e-06 PS=6.7e-06 NRD=0.085 NRS=0.085 $X=257225 $Y=130250 $D=41
M83 VDDA 7 VOUT VDDA pmos4 L=5e-06 W=5e-06 AD=4.25e-12 AS=4.25e-12 PD=6.7e-06 PS=6.7e-06 NRD=0.085 NRS=0.085 $X=257225 $Y=144550 $D=41
M84 VDDA 7 VOUT VDDA pmos4 L=5e-06 W=5e-06 AD=4.25e-12 AS=4.25e-12 PD=6.7e-06 PS=6.7e-06 NRD=0.085 NRS=0.085 $X=257225 $Y=158850 $D=41
M85 VDDA 7 VOUT VDDA pmos4 L=5e-06 W=5e-06 AD=4.25e-12 AS=4.25e-12 PD=6.7e-06 PS=6.7e-06 NRD=0.085 NRS=0.085 $X=257225 $Y=173150 $D=41
M86 VDDA 7 VOUT VDDA pmos4 L=5e-06 W=5e-06 AD=4.25e-12 AS=4.25e-12 PD=6.7e-06 PS=6.7e-06 NRD=0.085 NRS=0.085 $X=257225 $Y=187450 $D=41
M87 VDDA 7 VOUT VDDA pmos4 L=5e-06 W=5e-06 AD=4.25e-12 AS=4.25e-12 PD=6.7e-06 PS=6.7e-06 NRD=0.085 NRS=0.085 $X=264525 $Y=87350 $D=41
M88 VDDA 7 VOUT VDDA pmos4 L=5e-06 W=5e-06 AD=4.25e-12 AS=4.25e-12 PD=6.7e-06 PS=6.7e-06 NRD=0.085 NRS=0.085 $X=264525 $Y=101650 $D=41
M89 VDDA 7 VOUT VDDA pmos4 L=5e-06 W=5e-06 AD=4.25e-12 AS=4.25e-12 PD=6.7e-06 PS=6.7e-06 NRD=0.085 NRS=0.085 $X=264525 $Y=115950 $D=41
M90 VDDA 7 VOUT VDDA pmos4 L=5e-06 W=5e-06 AD=4.25e-12 AS=4.25e-12 PD=6.7e-06 PS=6.7e-06 NRD=0.085 NRS=0.085 $X=264525 $Y=130250 $D=41
M91 VDDA 7 VOUT VDDA pmos4 L=5e-06 W=5e-06 AD=4.25e-12 AS=4.25e-12 PD=6.7e-06 PS=6.7e-06 NRD=0.085 NRS=0.085 $X=264525 $Y=144550 $D=41
M92 VDDA 7 VOUT VDDA pmos4 L=5e-06 W=5e-06 AD=4.25e-12 AS=4.25e-12 PD=6.7e-06 PS=6.7e-06 NRD=0.085 NRS=0.085 $X=264525 $Y=158850 $D=41
M93 VDDA 7 VOUT VDDA pmos4 L=5e-06 W=5e-06 AD=4.25e-12 AS=4.25e-12 PD=6.7e-06 PS=6.7e-06 NRD=0.085 NRS=0.085 $X=264525 $Y=173150 $D=41
M94 VDDA 7 VOUT VDDA pmos4 L=5e-06 W=5e-06 AD=4.25e-12 AS=4.25e-12 PD=6.7e-06 PS=6.7e-06 NRD=0.085 NRS=0.085 $X=264525 $Y=187450 $D=41
M95 VDDA 7 VOUT VDDA pmos4 L=5e-06 W=5e-06 AD=4.25e-12 AS=4.25e-12 PD=6.7e-06 PS=6.7e-06 NRD=0.085 NRS=0.085 $X=271825 $Y=87350 $D=41
M96 VDDA 7 VOUT VDDA pmos4 L=5e-06 W=5e-06 AD=4.25e-12 AS=4.25e-12 PD=6.7e-06 PS=6.7e-06 NRD=0.085 NRS=0.085 $X=271825 $Y=101650 $D=41
M97 VDDA 7 VOUT VDDA pmos4 L=5e-06 W=5e-06 AD=4.25e-12 AS=4.25e-12 PD=6.7e-06 PS=6.7e-06 NRD=0.085 NRS=0.085 $X=271825 $Y=115950 $D=41
M98 VDDA 7 VOUT VDDA pmos4 L=5e-06 W=5e-06 AD=4.25e-12 AS=4.25e-12 PD=6.7e-06 PS=6.7e-06 NRD=0.085 NRS=0.085 $X=271825 $Y=130250 $D=41
M99 VDDA 7 VOUT VDDA pmos4 L=5e-06 W=5e-06 AD=4.25e-12 AS=4.25e-12 PD=6.7e-06 PS=6.7e-06 NRD=0.085 NRS=0.085 $X=271825 $Y=144550 $D=41
M100 VDDA 7 VOUT VDDA pmos4 L=5e-06 W=5e-06 AD=4.25e-12 AS=4.25e-12 PD=6.7e-06 PS=6.7e-06 NRD=0.085 NRS=0.085 $X=271825 $Y=158850 $D=41
M101 VDDA 7 VOUT VDDA pmos4 L=5e-06 W=5e-06 AD=4.25e-12 AS=4.25e-12 PD=6.7e-06 PS=6.7e-06 NRD=0.085 NRS=0.085 $X=271825 $Y=173150 $D=41
M102 VDDA 7 VOUT VDDA pmos4 L=5e-06 W=5e-06 AD=4.25e-12 AS=4.25e-12 PD=6.7e-06 PS=6.7e-06 NRD=0.085 NRS=0.085 $X=271825 $Y=187450 $D=41
M103 VDDA 7 VOUT VDDA pmos4 L=5e-06 W=5e-06 AD=4.25e-12 AS=4.25e-12 PD=6.7e-06 PS=6.7e-06 NRD=0.085 NRS=0.085 $X=279125 $Y=87350 $D=41
M104 VDDA 7 VOUT VDDA pmos4 L=5e-06 W=5e-06 AD=4.25e-12 AS=4.25e-12 PD=6.7e-06 PS=6.7e-06 NRD=0.085 NRS=0.085 $X=279125 $Y=101650 $D=41
M105 VDDA 7 VOUT VDDA pmos4 L=5e-06 W=5e-06 AD=4.25e-12 AS=4.25e-12 PD=6.7e-06 PS=6.7e-06 NRD=0.085 NRS=0.085 $X=279125 $Y=115950 $D=41
M106 VDDA 7 VOUT VDDA pmos4 L=5e-06 W=5e-06 AD=4.25e-12 AS=4.25e-12 PD=6.7e-06 PS=6.7e-06 NRD=0.085 NRS=0.085 $X=279125 $Y=130250 $D=41
M107 VDDA 7 VOUT VDDA pmos4 L=5e-06 W=5e-06 AD=4.25e-12 AS=4.25e-12 PD=6.7e-06 PS=6.7e-06 NRD=0.085 NRS=0.085 $X=279125 $Y=144550 $D=41
M108 VDDA 7 VOUT VDDA pmos4 L=5e-06 W=5e-06 AD=4.25e-12 AS=4.25e-12 PD=6.7e-06 PS=6.7e-06 NRD=0.085 NRS=0.085 $X=279125 $Y=158850 $D=41
M109 VDDA 7 VOUT VDDA pmos4 L=5e-06 W=5e-06 AD=4.25e-12 AS=4.25e-12 PD=6.7e-06 PS=6.7e-06 NRD=0.085 NRS=0.085 $X=279125 $Y=173150 $D=41
M110 VDDA 7 VOUT VDDA pmos4 L=5e-06 W=5e-06 AD=4.25e-12 AS=4.25e-12 PD=6.7e-06 PS=6.7e-06 NRD=0.085 NRS=0.085 $X=279125 $Y=187450 $D=41
M111 VDDA 7 VOUT VDDA pmos4 L=5e-06 W=5e-06 AD=4.25e-12 AS=4.25e-12 PD=6.7e-06 PS=6.7e-06 NRD=0.085 NRS=0.085 $X=286425 $Y=87350 $D=41
M112 VDDA 7 VOUT VDDA pmos4 L=5e-06 W=5e-06 AD=4.25e-12 AS=4.25e-12 PD=6.7e-06 PS=6.7e-06 NRD=0.085 NRS=0.085 $X=286425 $Y=101650 $D=41
M113 VDDA 7 VOUT VDDA pmos4 L=5e-06 W=5e-06 AD=4.25e-12 AS=4.25e-12 PD=6.7e-06 PS=6.7e-06 NRD=0.085 NRS=0.085 $X=286425 $Y=115950 $D=41
M114 VDDA 7 VOUT VDDA pmos4 L=5e-06 W=5e-06 AD=4.25e-12 AS=4.25e-12 PD=6.7e-06 PS=6.7e-06 NRD=0.085 NRS=0.085 $X=286425 $Y=130250 $D=41
M115 VDDA 7 VOUT VDDA pmos4 L=5e-06 W=5e-06 AD=4.25e-12 AS=4.25e-12 PD=6.7e-06 PS=6.7e-06 NRD=0.085 NRS=0.085 $X=286425 $Y=144550 $D=41
M116 VDDA 7 VOUT VDDA pmos4 L=5e-06 W=5e-06 AD=4.25e-12 AS=4.25e-12 PD=6.7e-06 PS=6.7e-06 NRD=0.085 NRS=0.085 $X=286425 $Y=158850 $D=41
M117 VDDA 7 VOUT VDDA pmos4 L=5e-06 W=5e-06 AD=4.25e-12 AS=4.25e-12 PD=6.7e-06 PS=6.7e-06 NRD=0.085 NRS=0.085 $X=286425 $Y=173150 $D=41
M118 VDDA 7 VOUT VDDA pmos4 L=5e-06 W=5e-06 AD=4.25e-12 AS=4.25e-12 PD=6.7e-06 PS=6.7e-06 NRD=0.085 NRS=0.085 $X=286425 $Y=187450 $D=41
M119 VDDA 7 VOUT VDDA pmos4 L=5e-06 W=5e-06 AD=4.25e-12 AS=4.25e-12 PD=6.7e-06 PS=6.7e-06 NRD=0.085 NRS=0.085 $X=293725 $Y=87350 $D=41
M120 VDDA 7 VOUT VDDA pmos4 L=5e-06 W=5e-06 AD=4.25e-12 AS=4.25e-12 PD=6.7e-06 PS=6.7e-06 NRD=0.085 NRS=0.085 $X=293725 $Y=101650 $D=41
M121 VDDA 7 VOUT VDDA pmos4 L=5e-06 W=5e-06 AD=4.25e-12 AS=4.25e-12 PD=6.7e-06 PS=6.7e-06 NRD=0.085 NRS=0.085 $X=293725 $Y=115950 $D=41
M122 VDDA 7 VOUT VDDA pmos4 L=5e-06 W=5e-06 AD=4.25e-12 AS=4.25e-12 PD=6.7e-06 PS=6.7e-06 NRD=0.085 NRS=0.085 $X=293725 $Y=130250 $D=41
M123 VDDA 7 VOUT VDDA pmos4 L=5e-06 W=5e-06 AD=4.25e-12 AS=4.25e-12 PD=6.7e-06 PS=6.7e-06 NRD=0.085 NRS=0.085 $X=293725 $Y=144550 $D=41
M124 VDDA 7 VOUT VDDA pmos4 L=5e-06 W=5e-06 AD=4.25e-12 AS=4.25e-12 PD=6.7e-06 PS=6.7e-06 NRD=0.085 NRS=0.085 $X=293725 $Y=158850 $D=41
M125 VDDA 7 VOUT VDDA pmos4 L=5e-06 W=5e-06 AD=4.25e-12 AS=4.25e-12 PD=6.7e-06 PS=6.7e-06 NRD=0.085 NRS=0.085 $X=293725 $Y=173150 $D=41
M126 VDDA 7 VOUT VDDA pmos4 L=5e-06 W=5e-06 AD=4.25e-12 AS=4.25e-12 PD=6.7e-06 PS=6.7e-06 NRD=0.085 NRS=0.085 $X=293725 $Y=187450 $D=41
M127 VDDA 7 VOUT VDDA pmos4 L=5e-06 W=5e-06 AD=4.25e-12 AS=4.25e-12 PD=6.7e-06 PS=6.7e-06 NRD=0.085 NRS=0.085 $X=301025 $Y=87350 $D=41
M128 VDDA 7 VOUT VDDA pmos4 L=5e-06 W=5e-06 AD=4.25e-12 AS=4.25e-12 PD=6.7e-06 PS=6.7e-06 NRD=0.085 NRS=0.085 $X=301025 $Y=101650 $D=41
M129 VDDA 7 VOUT VDDA pmos4 L=5e-06 W=5e-06 AD=4.25e-12 AS=4.25e-12 PD=6.7e-06 PS=6.7e-06 NRD=0.085 NRS=0.085 $X=301025 $Y=115950 $D=41
M130 VDDA 7 VOUT VDDA pmos4 L=5e-06 W=5e-06 AD=4.25e-12 AS=4.25e-12 PD=6.7e-06 PS=6.7e-06 NRD=0.085 NRS=0.085 $X=301025 $Y=130250 $D=41
M131 VDDA 7 VOUT VDDA pmos4 L=5e-06 W=5e-06 AD=4.25e-12 AS=4.25e-12 PD=6.7e-06 PS=6.7e-06 NRD=0.085 NRS=0.085 $X=301025 $Y=144550 $D=41
M132 VDDA 7 VOUT VDDA pmos4 L=5e-06 W=5e-06 AD=4.25e-12 AS=4.25e-12 PD=6.7e-06 PS=6.7e-06 NRD=0.085 NRS=0.085 $X=301025 $Y=158850 $D=41
M133 VDDA 7 VOUT VDDA pmos4 L=5e-06 W=5e-06 AD=4.25e-12 AS=4.25e-12 PD=6.7e-06 PS=6.7e-06 NRD=0.085 NRS=0.085 $X=301025 $Y=173150 $D=41
M134 VDDA 7 VOUT VDDA pmos4 L=5e-06 W=5e-06 AD=4.25e-12 AS=4.25e-12 PD=6.7e-06 PS=6.7e-06 NRD=0.085 NRS=0.085 $X=301025 $Y=187450 $D=41
M135 VDDA 7 VOUT VDDA pmos4 L=5e-06 W=5e-06 AD=4.25e-12 AS=4.25e-12 PD=6.7e-06 PS=6.7e-06 NRD=0.085 NRS=0.085 $X=308325 $Y=87350 $D=41
M136 VDDA 7 VOUT VDDA pmos4 L=5e-06 W=5e-06 AD=4.25e-12 AS=4.25e-12 PD=6.7e-06 PS=6.7e-06 NRD=0.085 NRS=0.085 $X=308325 $Y=101650 $D=41
M137 VDDA 7 VOUT VDDA pmos4 L=5e-06 W=5e-06 AD=4.25e-12 AS=4.25e-12 PD=6.7e-06 PS=6.7e-06 NRD=0.085 NRS=0.085 $X=308325 $Y=115950 $D=41
M138 VDDA 7 3 VDDA pmos4 L=5e-06 W=5e-06 AD=4.25e-12 AS=4.25e-12 PD=6.7e-06 PS=6.7e-06 NRD=0.085 NRS=0.085 $X=308325 $Y=130250 $D=41
M139 VDDA 7 3 VDDA pmos4 L=5e-06 W=5e-06 AD=4.25e-12 AS=4.25e-12 PD=6.7e-06 PS=6.7e-06 NRD=0.085 NRS=0.085 $X=308325 $Y=144550 $D=41
M140 VDDA 7 VOUT VDDA pmos4 L=5e-06 W=5e-06 AD=4.25e-12 AS=4.25e-12 PD=6.7e-06 PS=6.7e-06 NRD=0.085 NRS=0.085 $X=308325 $Y=158850 $D=41
M141 VDDA 7 VOUT VDDA pmos4 L=5e-06 W=5e-06 AD=4.25e-12 AS=4.25e-12 PD=6.7e-06 PS=6.7e-06 NRD=0.085 NRS=0.085 $X=308325 $Y=173150 $D=41
M142 VDDA 7 VOUT VDDA pmos4 L=5e-06 W=5e-06 AD=4.25e-12 AS=4.25e-12 PD=6.7e-06 PS=6.7e-06 NRD=0.085 NRS=0.085 $X=308325 $Y=187450 $D=41
M143 VDDA 7 VOUT VDDA pmos4 L=5e-06 W=5e-06 AD=4.25e-12 AS=4.25e-12 PD=6.7e-06 PS=6.7e-06 NRD=0.085 NRS=0.085 $X=315625 $Y=87350 $D=41
M144 VDDA 7 VOUT VDDA pmos4 L=5e-06 W=5e-06 AD=4.25e-12 AS=4.25e-12 PD=6.7e-06 PS=6.7e-06 NRD=0.085 NRS=0.085 $X=315625 $Y=101650 $D=41
M145 VDDA 7 VOUT VDDA pmos4 L=5e-06 W=5e-06 AD=4.25e-12 AS=4.25e-12 PD=6.7e-06 PS=6.7e-06 NRD=0.085 NRS=0.085 $X=315625 $Y=115950 $D=41
M146 VDDA 7 3 VDDA pmos4 L=5e-06 W=5e-06 AD=4.25e-12 AS=4.25e-12 PD=6.7e-06 PS=6.7e-06 NRD=0.085 NRS=0.085 $X=315625 $Y=130250 $D=41
M147 VDDA 7 3 VDDA pmos4 L=5e-06 W=5e-06 AD=4.25e-12 AS=4.25e-12 PD=6.7e-06 PS=6.7e-06 NRD=0.085 NRS=0.085 $X=315625 $Y=144550 $D=41
M148 VDDA 7 VOUT VDDA pmos4 L=5e-06 W=5e-06 AD=4.25e-12 AS=4.25e-12 PD=6.7e-06 PS=6.7e-06 NRD=0.085 NRS=0.085 $X=315625 $Y=158850 $D=41
M149 VDDA 7 VOUT VDDA pmos4 L=5e-06 W=5e-06 AD=4.25e-12 AS=4.25e-12 PD=6.7e-06 PS=6.7e-06 NRD=0.085 NRS=0.085 $X=315625 $Y=173150 $D=41
M150 VDDA 7 VOUT VDDA pmos4 L=5e-06 W=5e-06 AD=4.25e-12 AS=4.25e-12 PD=6.7e-06 PS=6.7e-06 NRD=0.085 NRS=0.085 $X=315625 $Y=187450 $D=41
M151 VDDA 7 VOUT VDDA pmos4 L=5e-06 W=5e-06 AD=4.25e-12 AS=4.25e-12 PD=6.7e-06 PS=6.7e-06 NRD=0.085 NRS=0.085 $X=322925 $Y=87350 $D=41
M152 VDDA 7 VOUT VDDA pmos4 L=5e-06 W=5e-06 AD=4.25e-12 AS=4.25e-12 PD=6.7e-06 PS=6.7e-06 NRD=0.085 NRS=0.085 $X=322925 $Y=101650 $D=41
M153 VDDA 7 VOUT VDDA pmos4 L=5e-06 W=5e-06 AD=4.25e-12 AS=4.25e-12 PD=6.7e-06 PS=6.7e-06 NRD=0.085 NRS=0.085 $X=322925 $Y=115950 $D=41
M154 VDDA 7 7 VDDA pmos4 L=5e-06 W=5e-06 AD=4.25e-12 AS=4.25e-12 PD=6.7e-06 PS=6.7e-06 NRD=0.085 NRS=0.085 $X=322925 $Y=130250 $D=41
M155 VDDA 7 3 VDDA pmos4 L=5e-06 W=5e-06 AD=4.25e-12 AS=4.25e-12 PD=6.7e-06 PS=6.7e-06 NRD=0.085 NRS=0.085 $X=322925 $Y=144550 $D=41
M156 VDDA 7 VOUT VDDA pmos4 L=5e-06 W=5e-06 AD=4.25e-12 AS=4.25e-12 PD=6.7e-06 PS=6.7e-06 NRD=0.085 NRS=0.085 $X=322925 $Y=158850 $D=41
M157 VDDA 7 VOUT VDDA pmos4 L=5e-06 W=5e-06 AD=4.25e-12 AS=4.25e-12 PD=6.7e-06 PS=6.7e-06 NRD=0.085 NRS=0.085 $X=322925 $Y=173150 $D=41
M158 VDDA 7 VOUT VDDA pmos4 L=5e-06 W=5e-06 AD=4.25e-12 AS=4.25e-12 PD=6.7e-06 PS=6.7e-06 NRD=0.085 NRS=0.085 $X=322925 $Y=187450 $D=41
C159 GNDA VDDA $[cpolya] $A=1000 $P=130 $X=18350 $Y=35525 $D=58
C160 GNDA VDDA $[cpolya] $A=3500 $P=330 $X=205150 $Y=20700 $D=58
X209 VDDA ICV_4 $T=226575 73050 0 90 $X=218675 $Y=71850
X210 VDDA ICV_4 $T=226575 87350 0 90 $X=218675 $Y=86150
X211 VDDA ICV_4 $T=226575 101650 0 90 $X=218675 $Y=100450
X212 VDDA ICV_4 $T=226575 115950 0 90 $X=218675 $Y=114750
X213 VDDA ICV_4 $T=226575 130250 0 90 $X=218675 $Y=129050
X214 VDDA ICV_4 $T=226575 144550 0 90 $X=218675 $Y=143350
X215 VDDA ICV_4 $T=226575 158850 0 90 $X=218675 $Y=157650
X216 VDDA ICV_4 $T=226575 173150 0 90 $X=218675 $Y=171950
X217 VDDA ICV_4 $T=226575 187450 0 90 $X=218675 $Y=186250
X218 VDDA ICV_4 $T=226575 201750 0 90 $X=218675 $Y=200550
X221 GNDA 7 IBIAS nmos4_CDNS_780735627175 $T=182025 26100 0 90 $X=170075 $Y=25700
X222 GNDA IBIAS IBIAS nmos4_CDNS_780735627175 $T=183125 26100 1 90 $X=182875 $Y=25700
X225 GNDA 1 1 nmos4_CDNS_780735627174 $T=150275 26100 0 90 $X=144325 $Y=25700
X226 GNDA 2 1 nmos4_CDNS_780735627174 $T=151375 26100 1 90 $X=151125 $Y=25700
X227 VOUT 4 cpolyc_CDNS_780735627172 $T=17225 138850 0 0 $X=15875 $Y=137500
X228 VOUT 4 cpolyc_CDNS_780735627172 $T=194375 138850 1 180 $X=106475 $Y=137500
X229 3 1 2 9 VIN VDDA ICV_6 $T=105750 34800 0 90 $X=100850 $Y=33600
X230 3 2 1 VIN 9 VDDA ICV_6 $T=105750 52600 0 90 $X=100850 $Y=51400
X231 17 9 rpolyhc_CDNS_780735627170 $T=82025 116350 1 0 $X=76025 $Y=104700
X232 12 17 rpolyhc_CDNS_780735627170 $T=131025 126650 0 180 $X=76025 $Y=115000
X233 VOUT 14 13 ICV_7 $T=27025 88750 0 0 $X=21025 $Y=84100
X234 13 15 12 ICV_7 $T=27025 109350 0 0 $X=21025 $Y=104700
X235 CBUF 16 9 ICV_7 $T=131025 88750 1 180 $X=76025 $Y=84100
X236 3 2 1 VDDA VIN 9 ICV_8 $T=71350 34800 0 90 $X=66450 $Y=33600
X237 3 1 2 VDDA 9 VIN ICV_8 $T=71350 52600 0 90 $X=66450 $Y=51400
.ENDS
***************************************
.SUBCKT rpolyhc_CDNS_7807356271774 1
** N=2 EP=1 IP=0 FDC=1
R0 1 1 L=4.99897e-06 W=8e-07 $[rpolyh] $X=600 $Y=0 $D=17
.ENDS
***************************************
.SUBCKT rpolyhc_CDNS_7807356271776 1 2
** N=3 EP=2 IP=0 FDC=1
R0 1 2 L=0.00049995 W=8e-07 $[rpolyh] $X=-800 $Y=1550 $D=18
.ENDS
***************************************
.SUBCKT pmos4_CDNS_7807356271735 1 2 3
** N=4 EP=3 IP=0 FDC=1
M0 2 3 1 1 pmos4 L=3.5e-07 W=1.4e-06 AD=1.19e-12 AS=1.19e-12 PD=3.1e-06 PS=3.1e-06 NRD=0.303571 NRS=0.303571 $X=0 $Y=850 $D=41
.ENDS
***************************************
.SUBCKT nmos4_CDNS_7807356271734 1 2 3
** N=3 EP=3 IP=0 FDC=1
M0 2 3 1 1 nmos4 L=3.5e-07 W=8e-07 AD=6.8e-13 AS=6.8e-13 PD=2.5e-06 PS=2.5e-06 NRD=0.53125 NRS=0.53125 $X=0 $Y=850 $D=37
.ENDS
***************************************
.SUBCKT pmos4_CDNS_7807356271784 1 2 3 5
** N=5 EP=4 IP=0 FDC=2
M0 2 3 1 5 pmos4 L=3.5e-07 W=1e-05 AD=5e-12 AS=8.5e-12 PD=1e-06 PS=1.17e-05 NRD=0.0425 NRS=0.0425 $X=0 $Y=850 $D=41
M1 1 3 2 5 pmos4 L=3.5e-07 W=1e-05 AD=8.5e-12 AS=5e-12 PD=1.17e-05 PS=1e-06 NRD=0.0425 NRS=0.0425 $X=0 $Y=2200 $D=41
.ENDS
***************************************
.SUBCKT nmos4_CDNS_7807356271783 1 2 3 4
** N=4 EP=4 IP=0 FDC=1
M0 2 3 1 4 nmos4 L=3.5e-07 W=1e-05 AD=8.5e-12 AS=8.5e-12 PD=1.17e-05 PS=1.17e-05 NRD=0.0425 NRS=0.0425 $X=0 $Y=850 $D=37
.ENDS
***************************************
.SUBCKT mux21 A0 S C GNDA VDDA
** N=7 EP=5 IP=25 FDC=10
D0 GNDA VDDA p_nwd AREA=23.625 PJ=19.5 $X=2300 $Y=10500 $D=87
D1 GNDA VDDA p_nwd AREA=197.12 PJ=56.4 $X=7850 $Y=2100 $D=87
X2 VDDA 4 S pmos4_CDNS_7807356271735 $T=3525 13100 0 270 $X=2325 $Y=10500
X3 GNDA 4 S nmos4_CDNS_7807356271734 $T=3525 9125 0 270 $X=3275 $Y=7925
X4 A0 C S VDDA pmos4_CDNS_7807356271784 $T=13950 4800 0 90 $X=9350 $Y=3600
X5 A1 C 4 VDDA pmos4_CDNS_7807356271784 $T=17950 4800 0 90 $X=13350 $Y=3600
X6 C A1 S GNDA nmos4_CDNS_7807356271783 $T=23900 4800 0 90 $X=21600 $Y=4400
X7 C A0 4 GNDA nmos4_CDNS_7807356271783 $T=25000 4800 1 90 $X=24750 $Y=4400
.ENDS
***************************************
.SUBCKT cpolyc_CDNS_7807356271777 2 3
** N=3 EP=2 IP=0 FDC=1
C0 2 3 $[cpolya] $A=1230.11 $P=140.3 $X=1800 $Y=1000 $D=58
.ENDS
***************************************
.SUBCKT nmos4_CDNS_7807356271761 1 2 3 4
** N=4 EP=4 IP=0 FDC=4
M0 2 3 1 4 nmos4 L=1e-06 W=5e-06 AD=2.5e-12 AS=4.25e-12 PD=1e-06 PS=6.7e-06 NRD=0.085 NRS=0.085 $X=0 $Y=850 $D=37
M1 1 3 2 4 nmos4 L=1e-06 W=5e-06 AD=2.5e-12 AS=2.5e-12 PD=1e-06 PS=1e-06 NRD=0.085 NRS=0.085 $X=0 $Y=2850 $D=37
M2 2 3 1 4 nmos4 L=1e-06 W=5e-06 AD=2.5e-12 AS=2.5e-12 PD=1e-06 PS=1e-06 NRD=0.085 NRS=0.085 $X=0 $Y=4850 $D=37
M3 1 3 2 4 nmos4 L=1e-06 W=5e-06 AD=4.25e-12 AS=2.5e-12 PD=6.7e-06 PS=1e-06 NRD=0.085 NRS=0.085 $X=0 $Y=6850 $D=37
.ENDS
***************************************
.SUBCKT P1_C_CDNS_78073562717216
** N=2 EP=0 IP=0 FDC=0
.ENDS
***************************************
.SUBCKT P2_C_CDNS_78073562717290
** N=2 EP=0 IP=0 FDC=0
.ENDS
***************************************
.SUBCKT nmos4_CDNS_7807356271779
** N=3 EP=0 IP=0 FDC=0
.ENDS
***************************************
.SUBCKT ICV_9
** N=5 EP=0 IP=6 FDC=0
.ENDS
***************************************
.SUBCKT pmos4_CDNS_7807356271780
** N=4 EP=0 IP=0 FDC=0
.ENDS
***************************************
.SUBCKT ICV_10
** N=6 EP=0 IP=8 FDC=0
.ENDS
***************************************
.SUBCKT ICV_11 1 3 4 7 8
** N=10 EP=5 IP=12 FDC=2
M0 3 7 1 1 pmos4 L=4e-06 W=1e-05 AD=8.5e-12 AS=8.5e-12 PD=1.17e-05 PS=1.17e-05 NRD=0.0425 NRS=0.0425 $X=0 $Y=-11750 $D=41
M1 4 8 1 1 pmos4 L=4e-06 W=1e-05 AD=8.5e-12 AS=8.5e-12 PD=1.17e-05 PS=1.17e-05 NRD=0.0425 NRS=0.0425 $X=0 $Y=-5450 $D=41
.ENDS
***************************************
.SUBCKT nmos4_CDNS_7807356271772 1 2 3 4
** N=4 EP=4 IP=0 FDC=4
M0 2 3 1 4 nmos4 L=8e-06 W=5e-06 AD=2.5e-12 AS=4.25e-12 PD=1e-06 PS=6.7e-06 NRD=0.085 NRS=0.085 $X=0 $Y=850 $D=37
M1 1 3 2 4 nmos4 L=8e-06 W=5e-06 AD=2.5e-12 AS=2.5e-12 PD=1e-06 PS=1e-06 NRD=0.085 NRS=0.085 $X=0 $Y=9850 $D=37
M2 2 3 1 4 nmos4 L=8e-06 W=5e-06 AD=2.5e-12 AS=2.5e-12 PD=1e-06 PS=1e-06 NRD=0.085 NRS=0.085 $X=0 $Y=18850 $D=37
M3 1 3 2 4 nmos4 L=8e-06 W=5e-06 AD=4.25e-12 AS=2.5e-12 PD=6.7e-06 PS=1e-06 NRD=0.085 NRS=0.085 $X=0 $Y=27850 $D=37
.ENDS
***************************************
.SUBCKT P1_C_CDNS_78073562717282
** N=2 EP=0 IP=0 FDC=0
.ENDS
***************************************
.SUBCKT nmos4_CDNS_7807356271778 1 2 3
** N=3 EP=3 IP=0 FDC=1
M0 2 3 1 1 nmos4 L=1.2e-05 W=1e-05 AD=8.5e-12 AS=8.5e-12 PD=1.17e-05 PS=1.17e-05 NRD=0.0425 NRS=0.0425 $X=0 $Y=850 $D=37
.ENDS
***************************************
.SUBCKT ND_C_CDNS_78073562717279
** N=2 EP=0 IP=0 FDC=0
.ENDS
***************************************
.SUBCKT P1_C_CDNS_78073562717278
** N=2 EP=0 IP=0 FDC=0
.ENDS
***************************************
.SUBCKT pmos4_CDNS_7807356271773
** N=4 EP=0 IP=0 FDC=0
.ENDS
***************************************
.SUBCKT ICV_12
** N=6 EP=0 IP=8 FDC=0
.ENDS
***************************************
.SUBCKT ICV_13
** N=10 EP=0 IP=12 FDC=0
.ENDS
***************************************
.SUBCKT ICV_14 1
** N=13 EP=1 IP=34 FDC=2
M0 1 1 1 1 pmos4 L=1.5e-05 W=1e-05 AD=8.5e-12 AS=8.5e-12 PD=1.17e-05 PS=1.17e-05 NRD=0.0425 NRS=0.0425 $X=0 $Y=-206750 $D=42
M1 1 1 1 1 pmos4 L=1.5e-05 W=1e-05 AD=8.5e-12 AS=8.5e-12 PD=1.17e-05 PS=1.17e-05 NRD=0.0425 NRS=0.0425 $X=0 $Y=850 $D=42
.ENDS
***************************************
.SUBCKT VGA_1 VOUT VDDA 3 IBIAS GNDA VIN S<0> CVGA 9 S<1> S<2> 12 S<3>
** N=35 EP=13 IP=544 FDC=240
R0 17 12 L=0.00015005 W=2e-06 $[rpolyh] $X=357800 $Y=20625 $D=18
D1 GNDA VDDA p_nwd AREA=49208.1 PJ=902.6 $X=3975 $Y=-4625 $D=87
D2 GNDA 15 p_nwd AREA=5133.15 PJ=306.4 $X=281975 $Y=128550 $D=87
D3 GNDA GNDA p_nwd AREA=844.025 PJ=116.7 $X=353500 $Y=15975 $D=87
D4 GNDA 16 p_nwd AREA=718.23 PJ=107.2 $X=364275 $Y=45475 $D=87
D5 GNDA GNDA p_nwd AREA=17893.7 PJ=584 $X=418700 $Y=10850 $D=87
D6 GNDA GNDA p_nwd AREA=10153.5 PJ=438.05 $X=430525 $Y=101350 $D=87
D7 GNDA GNDA p_nwd AREA=2745.62 PJ=228.2 $X=564200 $Y=133450 $D=87
M8 GNDA GNDA GNDA GNDA nmos4 L=1.5e-05 W=7.5e-06 AD=6.375e-12 AS=6.375e-12 PD=9.2e-06 PS=9.2e-06 NRD=0.0566667 NRS=0.0566667 $X=292425 $Y=85550 $D=38
M9 GNDA GNDA GNDA GNDA nmos4 L=1.5e-05 W=7.5e-06 AD=6.375e-12 AS=6.375e-12 PD=9.2e-06 PS=9.2e-06 NRD=0.0566667 NRS=0.0566667 $X=292425 $Y=97850 $D=38
M10 GNDA GNDA GNDA GNDA nmos4 L=1.5e-05 W=7.5e-06 AD=6.375e-12 AS=6.375e-12 PD=9.2e-06 PS=9.2e-06 NRD=0.0566667 NRS=0.0566667 $X=378925 $Y=85550 $D=38
M11 GNDA GNDA GNDA GNDA nmos4 L=1.5e-05 W=7.5e-06 AD=6.375e-12 AS=6.375e-12 PD=9.2e-06 PS=9.2e-06 NRD=0.0566667 NRS=0.0566667 $X=378925 $Y=97850 $D=38
M12 3 3 GNDA GNDA nmos4 L=1.5e-05 W=7.5e-06 AD=6.375e-12 AS=6.375e-12 PD=9.2e-06 PS=9.2e-06 NRD=0.0566667 NRS=0.0566667 $X=309725 $Y=85550 $D=37
M13 17 3 GNDA GNDA nmos4 L=1.5e-05 W=7.5e-06 AD=6.375e-12 AS=6.375e-12 PD=9.2e-06 PS=9.2e-06 NRD=0.0566667 NRS=0.0566667 $X=309725 $Y=97850 $D=37
M14 17 3 GNDA GNDA nmos4 L=1.5e-05 W=7.5e-06 AD=6.375e-12 AS=6.375e-12 PD=9.2e-06 PS=9.2e-06 NRD=0.0566667 NRS=0.0566667 $X=327025 $Y=85550 $D=37
M15 3 3 GNDA GNDA nmos4 L=1.5e-05 W=7.5e-06 AD=6.375e-12 AS=6.375e-12 PD=9.2e-06 PS=9.2e-06 NRD=0.0566667 NRS=0.0566667 $X=327025 $Y=97850 $D=37
M16 17 3 GNDA GNDA nmos4 L=1.5e-05 W=7.5e-06 AD=6.375e-12 AS=6.375e-12 PD=9.2e-06 PS=9.2e-06 NRD=0.0566667 NRS=0.0566667 $X=344325 $Y=85550 $D=37
M17 3 3 GNDA GNDA nmos4 L=1.5e-05 W=7.5e-06 AD=6.375e-12 AS=6.375e-12 PD=9.2e-06 PS=9.2e-06 NRD=0.0566667 NRS=0.0566667 $X=344325 $Y=97850 $D=37
M18 3 3 GNDA GNDA nmos4 L=1.5e-05 W=7.5e-06 AD=6.375e-12 AS=6.375e-12 PD=9.2e-06 PS=9.2e-06 NRD=0.0566667 NRS=0.0566667 $X=361625 $Y=85550 $D=37
M19 17 3 GNDA GNDA nmos4 L=1.5e-05 W=7.5e-06 AD=6.375e-12 AS=6.375e-12 PD=9.2e-06 PS=9.2e-06 NRD=0.0566667 NRS=0.0566667 $X=361625 $Y=97850 $D=37
M20 VDDA VDDA VDDA VDDA pmos4 L=1.5e-05 W=1e-05 AD=8.5e-12 AS=8.5e-12 PD=1.17e-05 PS=1.17e-05 NRD=0.0425 NRS=0.0425 $X=43475 $Y=2725 $D=42
M21 VDDA VDDA VDDA VDDA pmos4 L=1.5e-05 W=1e-05 AD=8.5e-12 AS=8.5e-12 PD=1.17e-05 PS=1.17e-05 NRD=0.0425 NRS=0.0425 $X=43475 $Y=24525 $D=42
M22 VDDA VDDA VDDA VDDA pmos4 L=1.5e-05 W=1e-05 AD=8.5e-12 AS=8.5e-12 PD=1.17e-05 PS=1.17e-05 NRD=0.0425 NRS=0.0425 $X=43475 $Y=133525 $D=42
M23 VDDA VDDA VDDA VDDA pmos4 L=1.5e-05 W=1e-05 AD=8.5e-12 AS=8.5e-12 PD=1.17e-05 PS=1.17e-05 NRD=0.0425 NRS=0.0425 $X=43475 $Y=155325 $D=42
M24 VDDA VDDA VDDA VDDA pmos4 L=1.5e-05 W=1e-05 AD=8.5e-12 AS=8.5e-12 PD=1.17e-05 PS=1.17e-05 NRD=0.0425 NRS=0.0425 $X=60775 $Y=2725 $D=42
M25 VDDA VDDA VDDA VDDA pmos4 L=1.5e-05 W=1e-05 AD=8.5e-12 AS=8.5e-12 PD=1.17e-05 PS=1.17e-05 NRD=0.0425 NRS=0.0425 $X=60775 $Y=155325 $D=42
M26 VDDA VDDA VDDA VDDA pmos4 L=1.5e-05 W=1e-05 AD=8.5e-12 AS=8.5e-12 PD=1.17e-05 PS=1.17e-05 NRD=0.0425 NRS=0.0425 $X=78075 $Y=2725 $D=42
M27 VDDA VDDA VDDA VDDA pmos4 L=1.5e-05 W=1e-05 AD=8.5e-12 AS=8.5e-12 PD=1.17e-05 PS=1.17e-05 NRD=0.0425 NRS=0.0425 $X=78075 $Y=155325 $D=42
M28 VDDA VDDA VDDA VDDA pmos4 L=1.5e-05 W=1e-05 AD=8.5e-12 AS=8.5e-12 PD=1.17e-05 PS=1.17e-05 NRD=0.0425 NRS=0.0425 $X=95375 $Y=2725 $D=42
M29 VDDA VDDA VDDA VDDA pmos4 L=1.5e-05 W=1e-05 AD=8.5e-12 AS=8.5e-12 PD=1.17e-05 PS=1.17e-05 NRD=0.0425 NRS=0.0425 $X=95375 $Y=155325 $D=42
M30 VDDA VDDA VDDA VDDA pmos4 L=1.5e-05 W=1e-05 AD=8.5e-12 AS=8.5e-12 PD=1.17e-05 PS=1.17e-05 NRD=0.0425 NRS=0.0425 $X=112675 $Y=2725 $D=42
M31 VDDA VDDA VDDA VDDA pmos4 L=1.5e-05 W=1e-05 AD=8.5e-12 AS=8.5e-12 PD=1.17e-05 PS=1.17e-05 NRD=0.0425 NRS=0.0425 $X=112675 $Y=155325 $D=42
M32 VDDA VDDA VDDA VDDA pmos4 L=1.5e-05 W=1e-05 AD=8.5e-12 AS=8.5e-12 PD=1.17e-05 PS=1.17e-05 NRD=0.0425 NRS=0.0425 $X=129975 $Y=2725 $D=42
M33 VDDA VDDA VDDA VDDA pmos4 L=1.5e-05 W=1e-05 AD=8.5e-12 AS=8.5e-12 PD=1.17e-05 PS=1.17e-05 NRD=0.0425 NRS=0.0425 $X=129975 $Y=155325 $D=42
M34 VDDA VDDA VDDA VDDA pmos4 L=1.5e-05 W=1e-05 AD=8.5e-12 AS=8.5e-12 PD=1.17e-05 PS=1.17e-05 NRD=0.0425 NRS=0.0425 $X=147275 $Y=2725 $D=42
M35 VDDA VDDA VDDA VDDA pmos4 L=1.5e-05 W=1e-05 AD=8.5e-12 AS=8.5e-12 PD=1.17e-05 PS=1.17e-05 NRD=0.0425 NRS=0.0425 $X=147275 $Y=155325 $D=42
M36 VDDA VDDA VDDA VDDA pmos4 L=1.5e-05 W=1e-05 AD=8.5e-12 AS=8.5e-12 PD=1.17e-05 PS=1.17e-05 NRD=0.0425 NRS=0.0425 $X=164575 $Y=2725 $D=42
M37 VDDA VDDA VDDA VDDA pmos4 L=1.5e-05 W=1e-05 AD=8.5e-12 AS=8.5e-12 PD=1.17e-05 PS=1.17e-05 NRD=0.0425 NRS=0.0425 $X=164575 $Y=155325 $D=42
M38 VDDA VDDA VDDA VDDA pmos4 L=1.5e-05 W=1e-05 AD=8.5e-12 AS=8.5e-12 PD=1.17e-05 PS=1.17e-05 NRD=0.0425 NRS=0.0425 $X=181875 $Y=2725 $D=42
M39 VDDA VDDA VDDA VDDA pmos4 L=1.5e-05 W=1e-05 AD=8.5e-12 AS=8.5e-12 PD=1.17e-05 PS=1.17e-05 NRD=0.0425 NRS=0.0425 $X=181875 $Y=155325 $D=42
M40 VDDA VDDA VDDA VDDA pmos4 L=1.5e-05 W=1e-05 AD=8.5e-12 AS=8.5e-12 PD=1.17e-05 PS=1.17e-05 NRD=0.0425 NRS=0.0425 $X=199175 $Y=2725 $D=42
M41 VDDA VDDA VDDA VDDA pmos4 L=1.5e-05 W=1e-05 AD=8.5e-12 AS=8.5e-12 PD=1.17e-05 PS=1.17e-05 NRD=0.0425 NRS=0.0425 $X=199175 $Y=155325 $D=42
M42 VDDA VDDA VDDA VDDA pmos4 L=1.5e-05 W=1e-05 AD=8.5e-12 AS=8.5e-12 PD=1.17e-05 PS=1.17e-05 NRD=0.0425 NRS=0.0425 $X=216475 $Y=2725 $D=42
M43 VDDA VDDA VDDA VDDA pmos4 L=1.5e-05 W=1e-05 AD=8.5e-12 AS=8.5e-12 PD=1.17e-05 PS=1.17e-05 NRD=0.0425 NRS=0.0425 $X=216475 $Y=133525 $D=42
M44 VDDA VDDA VDDA VDDA pmos4 L=1.5e-05 W=1e-05 AD=8.5e-12 AS=8.5e-12 PD=1.17e-05 PS=1.17e-05 NRD=0.0425 NRS=0.0425 $X=216475 $Y=155325 $D=42
M45 15 15 15 15 pmos4 L=4e-06 W=1e-05 AD=8.5e-12 AS=8.5e-12 PD=1.17e-05 PS=1.17e-05 NRD=0.0425 NRS=0.0425 $X=297175 $Y=139900 $D=42
M46 15 15 15 15 pmos4 L=4e-06 W=1e-05 AD=8.5e-12 AS=8.5e-12 PD=1.17e-05 PS=1.17e-05 NRD=0.0425 NRS=0.0425 $X=297175 $Y=156700 $D=42
M47 15 15 15 15 pmos4 L=4e-06 W=1e-05 AD=8.5e-12 AS=8.5e-12 PD=1.17e-05 PS=1.17e-05 NRD=0.0425 NRS=0.0425 $X=366475 $Y=139900 $D=42
M48 15 15 15 15 pmos4 L=4e-06 W=1e-05 AD=8.5e-12 AS=8.5e-12 PD=1.17e-05 PS=1.17e-05 NRD=0.0425 NRS=0.0425 $X=366475 $Y=156700 $D=42
M49 VDDA 14 VOUT VDDA pmos4 L=1.5e-05 W=1e-05 AD=8.5e-12 AS=8.5e-12 PD=1.17e-05 PS=1.17e-05 NRD=0.0425 NRS=0.0425 $X=43475 $Y=46325 $D=41
M50 VDDA 14 VOUT VDDA pmos4 L=1.5e-05 W=1e-05 AD=8.5e-12 AS=8.5e-12 PD=1.17e-05 PS=1.17e-05 NRD=0.0425 NRS=0.0425 $X=43475 $Y=68125 $D=41
M51 VDDA 14 VOUT VDDA pmos4 L=1.5e-05 W=1e-05 AD=8.5e-12 AS=8.5e-12 PD=1.17e-05 PS=1.17e-05 NRD=0.0425 NRS=0.0425 $X=43475 $Y=89925 $D=41
M52 VDDA 14 VOUT VDDA pmos4 L=1.5e-05 W=1e-05 AD=8.5e-12 AS=8.5e-12 PD=1.17e-05 PS=1.17e-05 NRD=0.0425 NRS=0.0425 $X=43475 $Y=111725 $D=41
M53 VDDA 14 VOUT VDDA pmos4 L=1.5e-05 W=1e-05 AD=8.5e-12 AS=8.5e-12 PD=1.17e-05 PS=1.17e-05 NRD=0.0425 NRS=0.0425 $X=60775 $Y=24525 $D=41
M54 VDDA 14 VOUT VDDA pmos4 L=1.5e-05 W=1e-05 AD=8.5e-12 AS=8.5e-12 PD=1.17e-05 PS=1.17e-05 NRD=0.0425 NRS=0.0425 $X=60775 $Y=46325 $D=41
M55 VDDA 14 15 VDDA pmos4 L=1.5e-05 W=1e-05 AD=8.5e-12 AS=8.5e-12 PD=1.17e-05 PS=1.17e-05 NRD=0.0425 NRS=0.0425 $X=60775 $Y=68125 $D=41
M56 VDDA 14 VOUT VDDA pmos4 L=1.5e-05 W=1e-05 AD=8.5e-12 AS=8.5e-12 PD=1.17e-05 PS=1.17e-05 NRD=0.0425 NRS=0.0425 $X=60775 $Y=89925 $D=41
M57 VDDA 14 15 VDDA pmos4 L=1.5e-05 W=1e-05 AD=8.5e-12 AS=8.5e-12 PD=1.17e-05 PS=1.17e-05 NRD=0.0425 NRS=0.0425 $X=60775 $Y=111725 $D=41
M58 VDDA 14 VOUT VDDA pmos4 L=1.5e-05 W=1e-05 AD=8.5e-12 AS=8.5e-12 PD=1.17e-05 PS=1.17e-05 NRD=0.0425 NRS=0.0425 $X=60775 $Y=133525 $D=41
M59 VDDA 14 VOUT VDDA pmos4 L=1.5e-05 W=1e-05 AD=8.5e-12 AS=8.5e-12 PD=1.17e-05 PS=1.17e-05 NRD=0.0425 NRS=0.0425 $X=78075 $Y=24525 $D=41
M60 VDDA 14 15 VDDA pmos4 L=1.5e-05 W=1e-05 AD=8.5e-12 AS=8.5e-12 PD=1.17e-05 PS=1.17e-05 NRD=0.0425 NRS=0.0425 $X=78075 $Y=46325 $D=41
M61 VDDA 14 VOUT VDDA pmos4 L=1.5e-05 W=1e-05 AD=8.5e-12 AS=8.5e-12 PD=1.17e-05 PS=1.17e-05 NRD=0.0425 NRS=0.0425 $X=78075 $Y=68125 $D=41
M62 VDDA 14 14 VDDA pmos4 L=1.5e-05 W=1e-05 AD=8.5e-12 AS=8.5e-12 PD=1.17e-05 PS=1.17e-05 NRD=0.0425 NRS=0.0425 $X=78075 $Y=89925 $D=41
M63 VDDA 14 VOUT VDDA pmos4 L=1.5e-05 W=1e-05 AD=8.5e-12 AS=8.5e-12 PD=1.17e-05 PS=1.17e-05 NRD=0.0425 NRS=0.0425 $X=78075 $Y=111725 $D=41
M64 VDDA 14 VOUT VDDA pmos4 L=1.5e-05 W=1e-05 AD=8.5e-12 AS=8.5e-12 PD=1.17e-05 PS=1.17e-05 NRD=0.0425 NRS=0.0425 $X=78075 $Y=133525 $D=41
M65 VDDA 14 VOUT VDDA pmos4 L=1.5e-05 W=1e-05 AD=8.5e-12 AS=8.5e-12 PD=1.17e-05 PS=1.17e-05 NRD=0.0425 NRS=0.0425 $X=95375 $Y=24525 $D=41
M66 VDDA 14 VOUT VDDA pmos4 L=1.5e-05 W=1e-05 AD=8.5e-12 AS=8.5e-12 PD=1.17e-05 PS=1.17e-05 NRD=0.0425 NRS=0.0425 $X=95375 $Y=46325 $D=41
M67 VDDA 14 15 VDDA pmos4 L=1.5e-05 W=1e-05 AD=8.5e-12 AS=8.5e-12 PD=1.17e-05 PS=1.17e-05 NRD=0.0425 NRS=0.0425 $X=95375 $Y=68125 $D=41
M68 VDDA 14 VOUT VDDA pmos4 L=1.5e-05 W=1e-05 AD=8.5e-12 AS=8.5e-12 PD=1.17e-05 PS=1.17e-05 NRD=0.0425 NRS=0.0425 $X=95375 $Y=89925 $D=41
M69 VDDA 14 15 VDDA pmos4 L=1.5e-05 W=1e-05 AD=8.5e-12 AS=8.5e-12 PD=1.17e-05 PS=1.17e-05 NRD=0.0425 NRS=0.0425 $X=95375 $Y=111725 $D=41
M70 VDDA 14 VOUT VDDA pmos4 L=1.5e-05 W=1e-05 AD=8.5e-12 AS=8.5e-12 PD=1.17e-05 PS=1.17e-05 NRD=0.0425 NRS=0.0425 $X=95375 $Y=133525 $D=41
M71 VDDA 14 VOUT VDDA pmos4 L=1.5e-05 W=1e-05 AD=8.5e-12 AS=8.5e-12 PD=1.17e-05 PS=1.17e-05 NRD=0.0425 NRS=0.0425 $X=112675 $Y=24525 $D=41
M72 VDDA 14 VOUT VDDA pmos4 L=1.5e-05 W=1e-05 AD=8.5e-12 AS=8.5e-12 PD=1.17e-05 PS=1.17e-05 NRD=0.0425 NRS=0.0425 $X=112675 $Y=46325 $D=41
M73 VDDA 14 VOUT VDDA pmos4 L=1.5e-05 W=1e-05 AD=8.5e-12 AS=8.5e-12 PD=1.17e-05 PS=1.17e-05 NRD=0.0425 NRS=0.0425 $X=112675 $Y=68125 $D=41
M74 VDDA 14 VOUT VDDA pmos4 L=1.5e-05 W=1e-05 AD=8.5e-12 AS=8.5e-12 PD=1.17e-05 PS=1.17e-05 NRD=0.0425 NRS=0.0425 $X=112675 $Y=89925 $D=41
M75 VDDA 14 VOUT VDDA pmos4 L=1.5e-05 W=1e-05 AD=8.5e-12 AS=8.5e-12 PD=1.17e-05 PS=1.17e-05 NRD=0.0425 NRS=0.0425 $X=112675 $Y=111725 $D=41
M76 VDDA 14 VOUT VDDA pmos4 L=1.5e-05 W=1e-05 AD=8.5e-12 AS=8.5e-12 PD=1.17e-05 PS=1.17e-05 NRD=0.0425 NRS=0.0425 $X=112675 $Y=133525 $D=41
M77 VDDA 14 VOUT VDDA pmos4 L=1.5e-05 W=1e-05 AD=8.5e-12 AS=8.5e-12 PD=1.17e-05 PS=1.17e-05 NRD=0.0425 NRS=0.0425 $X=129975 $Y=24525 $D=41
M78 VDDA 14 VOUT VDDA pmos4 L=1.5e-05 W=1e-05 AD=8.5e-12 AS=8.5e-12 PD=1.17e-05 PS=1.17e-05 NRD=0.0425 NRS=0.0425 $X=129975 $Y=46325 $D=41
M79 VDDA 14 VOUT VDDA pmos4 L=1.5e-05 W=1e-05 AD=8.5e-12 AS=8.5e-12 PD=1.17e-05 PS=1.17e-05 NRD=0.0425 NRS=0.0425 $X=129975 $Y=68125 $D=41
M80 VDDA 14 16 VDDA pmos4 L=1.5e-05 W=1e-05 AD=8.5e-12 AS=8.5e-12 PD=1.17e-05 PS=1.17e-05 NRD=0.0425 NRS=0.0425 $X=129975 $Y=89925 $D=41
M81 VDDA 14 VOUT VDDA pmos4 L=1.5e-05 W=1e-05 AD=8.5e-12 AS=8.5e-12 PD=1.17e-05 PS=1.17e-05 NRD=0.0425 NRS=0.0425 $X=129975 $Y=111725 $D=41
M82 VDDA 14 VOUT VDDA pmos4 L=1.5e-05 W=1e-05 AD=8.5e-12 AS=8.5e-12 PD=1.17e-05 PS=1.17e-05 NRD=0.0425 NRS=0.0425 $X=129975 $Y=133525 $D=41
M83 VDDA 14 VOUT VDDA pmos4 L=1.5e-05 W=1e-05 AD=8.5e-12 AS=8.5e-12 PD=1.17e-05 PS=1.17e-05 NRD=0.0425 NRS=0.0425 $X=147275 $Y=24525 $D=41
M84 VDDA 14 VOUT VDDA pmos4 L=1.5e-05 W=1e-05 AD=8.5e-12 AS=8.5e-12 PD=1.17e-05 PS=1.17e-05 NRD=0.0425 NRS=0.0425 $X=147275 $Y=46325 $D=41
M85 VDDA 14 VOUT VDDA pmos4 L=1.5e-05 W=1e-05 AD=8.5e-12 AS=8.5e-12 PD=1.17e-05 PS=1.17e-05 NRD=0.0425 NRS=0.0425 $X=147275 $Y=68125 $D=41
M86 VDDA 14 VOUT VDDA pmos4 L=1.5e-05 W=1e-05 AD=8.5e-12 AS=8.5e-12 PD=1.17e-05 PS=1.17e-05 NRD=0.0425 NRS=0.0425 $X=147275 $Y=89925 $D=41
M87 VDDA 14 VOUT VDDA pmos4 L=1.5e-05 W=1e-05 AD=8.5e-12 AS=8.5e-12 PD=1.17e-05 PS=1.17e-05 NRD=0.0425 NRS=0.0425 $X=147275 $Y=111725 $D=41
M88 VDDA 14 VOUT VDDA pmos4 L=1.5e-05 W=1e-05 AD=8.5e-12 AS=8.5e-12 PD=1.17e-05 PS=1.17e-05 NRD=0.0425 NRS=0.0425 $X=147275 $Y=133525 $D=41
M89 VDDA 14 VOUT VDDA pmos4 L=1.5e-05 W=1e-05 AD=8.5e-12 AS=8.5e-12 PD=1.17e-05 PS=1.17e-05 NRD=0.0425 NRS=0.0425 $X=164575 $Y=24525 $D=41
M90 VDDA 14 15 VDDA pmos4 L=1.5e-05 W=1e-05 AD=8.5e-12 AS=8.5e-12 PD=1.17e-05 PS=1.17e-05 NRD=0.0425 NRS=0.0425 $X=164575 $Y=46325 $D=41
M91 VDDA 14 VOUT VDDA pmos4 L=1.5e-05 W=1e-05 AD=8.5e-12 AS=8.5e-12 PD=1.17e-05 PS=1.17e-05 NRD=0.0425 NRS=0.0425 $X=164575 $Y=68125 $D=41
M92 VDDA 14 15 VDDA pmos4 L=1.5e-05 W=1e-05 AD=8.5e-12 AS=8.5e-12 PD=1.17e-05 PS=1.17e-05 NRD=0.0425 NRS=0.0425 $X=164575 $Y=89925 $D=41
M93 VDDA 14 VOUT VDDA pmos4 L=1.5e-05 W=1e-05 AD=8.5e-12 AS=8.5e-12 PD=1.17e-05 PS=1.17e-05 NRD=0.0425 NRS=0.0425 $X=164575 $Y=111725 $D=41
M94 VDDA 14 VOUT VDDA pmos4 L=1.5e-05 W=1e-05 AD=8.5e-12 AS=8.5e-12 PD=1.17e-05 PS=1.17e-05 NRD=0.0425 NRS=0.0425 $X=164575 $Y=133525 $D=41
M95 VDDA 14 VOUT VDDA pmos4 L=1.5e-05 W=1e-05 AD=8.5e-12 AS=8.5e-12 PD=1.17e-05 PS=1.17e-05 NRD=0.0425 NRS=0.0425 $X=181875 $Y=24525 $D=41
M96 VDDA 14 VOUT VDDA pmos4 L=1.5e-05 W=1e-05 AD=8.5e-12 AS=8.5e-12 PD=1.17e-05 PS=1.17e-05 NRD=0.0425 NRS=0.0425 $X=181875 $Y=46325 $D=41
M97 VDDA 14 14 VDDA pmos4 L=1.5e-05 W=1e-05 AD=8.5e-12 AS=8.5e-12 PD=1.17e-05 PS=1.17e-05 NRD=0.0425 NRS=0.0425 $X=181875 $Y=68125 $D=41
M98 VDDA 14 VOUT VDDA pmos4 L=1.5e-05 W=1e-05 AD=8.5e-12 AS=8.5e-12 PD=1.17e-05 PS=1.17e-05 NRD=0.0425 NRS=0.0425 $X=181875 $Y=89925 $D=41
M99 VDDA 14 15 VDDA pmos4 L=1.5e-05 W=1e-05 AD=8.5e-12 AS=8.5e-12 PD=1.17e-05 PS=1.17e-05 NRD=0.0425 NRS=0.0425 $X=181875 $Y=111725 $D=41
M100 VDDA 14 VOUT VDDA pmos4 L=1.5e-05 W=1e-05 AD=8.5e-12 AS=8.5e-12 PD=1.17e-05 PS=1.17e-05 NRD=0.0425 NRS=0.0425 $X=181875 $Y=133525 $D=41
M101 VDDA 14 VOUT VDDA pmos4 L=1.5e-05 W=1e-05 AD=8.5e-12 AS=8.5e-12 PD=1.17e-05 PS=1.17e-05 NRD=0.0425 NRS=0.0425 $X=199175 $Y=24525 $D=41
M102 VDDA 14 15 VDDA pmos4 L=1.5e-05 W=1e-05 AD=8.5e-12 AS=8.5e-12 PD=1.17e-05 PS=1.17e-05 NRD=0.0425 NRS=0.0425 $X=199175 $Y=46325 $D=41
M103 VDDA 14 VOUT VDDA pmos4 L=1.5e-05 W=1e-05 AD=8.5e-12 AS=8.5e-12 PD=1.17e-05 PS=1.17e-05 NRD=0.0425 NRS=0.0425 $X=199175 $Y=68125 $D=41
M104 VDDA 14 15 VDDA pmos4 L=1.5e-05 W=1e-05 AD=8.5e-12 AS=8.5e-12 PD=1.17e-05 PS=1.17e-05 NRD=0.0425 NRS=0.0425 $X=199175 $Y=89925 $D=41
M105 VDDA 14 VOUT VDDA pmos4 L=1.5e-05 W=1e-05 AD=8.5e-12 AS=8.5e-12 PD=1.17e-05 PS=1.17e-05 NRD=0.0425 NRS=0.0425 $X=199175 $Y=111725 $D=41
M106 VDDA 14 VOUT VDDA pmos4 L=1.5e-05 W=1e-05 AD=8.5e-12 AS=8.5e-12 PD=1.17e-05 PS=1.17e-05 NRD=0.0425 NRS=0.0425 $X=199175 $Y=133525 $D=41
M107 VDDA 14 VOUT VDDA pmos4 L=1.5e-05 W=1e-05 AD=8.5e-12 AS=8.5e-12 PD=1.17e-05 PS=1.17e-05 NRD=0.0425 NRS=0.0425 $X=216475 $Y=24525 $D=41
M108 VDDA 14 VOUT VDDA pmos4 L=1.5e-05 W=1e-05 AD=8.5e-12 AS=8.5e-12 PD=1.17e-05 PS=1.17e-05 NRD=0.0425 NRS=0.0425 $X=216475 $Y=46325 $D=41
M109 VDDA 14 VOUT VDDA pmos4 L=1.5e-05 W=1e-05 AD=8.5e-12 AS=8.5e-12 PD=1.17e-05 PS=1.17e-05 NRD=0.0425 NRS=0.0425 $X=216475 $Y=68125 $D=41
M110 VDDA 14 VOUT VDDA pmos4 L=1.5e-05 W=1e-05 AD=8.5e-12 AS=8.5e-12 PD=1.17e-05 PS=1.17e-05 NRD=0.0425 NRS=0.0425 $X=216475 $Y=89925 $D=41
M111 VDDA 14 VOUT VDDA pmos4 L=1.5e-05 W=1e-05 AD=8.5e-12 AS=8.5e-12 PD=1.17e-05 PS=1.17e-05 NRD=0.0425 NRS=0.0425 $X=216475 $Y=111725 $D=41
M112 15 VIN 17 15 pmos4 L=4e-06 W=1e-05 AD=8.5e-12 AS=8.5e-12 PD=1.17e-05 PS=1.17e-05 NRD=0.0425 NRS=0.0425 $X=316075 $Y=139900 $D=41
M113 15 9 3 15 pmos4 L=4e-06 W=1e-05 AD=8.5e-12 AS=8.5e-12 PD=1.17e-05 PS=1.17e-05 NRD=0.0425 NRS=0.0425 $X=316075 $Y=156700 $D=41
M114 15 9 3 15 pmos4 L=4e-06 W=1e-05 AD=8.5e-12 AS=8.5e-12 PD=1.17e-05 PS=1.17e-05 NRD=0.0425 NRS=0.0425 $X=322375 $Y=139900 $D=41
M115 15 VIN 17 15 pmos4 L=4e-06 W=1e-05 AD=8.5e-12 AS=8.5e-12 PD=1.17e-05 PS=1.17e-05 NRD=0.0425 NRS=0.0425 $X=322375 $Y=156700 $D=41
M116 15 9 3 15 pmos4 L=4e-06 W=1e-05 AD=8.5e-12 AS=8.5e-12 PD=1.17e-05 PS=1.17e-05 NRD=0.0425 NRS=0.0425 $X=341275 $Y=139900 $D=41
M117 15 VIN 17 15 pmos4 L=4e-06 W=1e-05 AD=8.5e-12 AS=8.5e-12 PD=1.17e-05 PS=1.17e-05 NRD=0.0425 NRS=0.0425 $X=341275 $Y=156700 $D=41
M118 15 VIN 17 15 pmos4 L=4e-06 W=1e-05 AD=8.5e-12 AS=8.5e-12 PD=1.17e-05 PS=1.17e-05 NRD=0.0425 NRS=0.0425 $X=347575 $Y=139900 $D=41
M119 15 9 3 15 pmos4 L=4e-06 W=1e-05 AD=8.5e-12 AS=8.5e-12 PD=1.17e-05 PS=1.17e-05 NRD=0.0425 NRS=0.0425 $X=347575 $Y=156700 $D=41
M120 GNDA GNDA 16 16 pmos4 L=3.5e-07 W=1e-05 AD=5e-12 AS=8.5e-12 PD=1e-06 PS=1.17e-05 NRD=0.0425 NRS=0.0425 $X=371475 $Y=56825 $D=41
M121 16 GNDA GNDA 16 pmos4 L=3.5e-07 W=1e-05 AD=5e-12 AS=5e-12 PD=1e-06 PS=1e-06 NRD=0.0425 NRS=0.0425 $X=372825 $Y=56825 $D=41
M122 GNDA GNDA 16 16 pmos4 L=3.5e-07 W=1e-05 AD=5e-12 AS=5e-12 PD=1e-06 PS=1e-06 NRD=0.0425 NRS=0.0425 $X=374175 $Y=56825 $D=41
M123 16 GNDA GNDA 16 pmos4 L=3.5e-07 W=1e-05 AD=5e-12 AS=5e-12 PD=1e-06 PS=1e-06 NRD=0.0425 NRS=0.0425 $X=375525 $Y=56825 $D=41
M124 GNDA GNDA 16 16 pmos4 L=3.5e-07 W=1e-05 AD=5e-12 AS=5e-12 PD=1e-06 PS=1e-06 NRD=0.0425 NRS=0.0425 $X=376875 $Y=56825 $D=41
M125 16 GNDA GNDA 16 pmos4 L=3.5e-07 W=1e-05 AD=5e-12 AS=5e-12 PD=1e-06 PS=1e-06 NRD=0.0425 NRS=0.0425 $X=378225 $Y=56825 $D=41
M126 GNDA GNDA 16 16 pmos4 L=3.5e-07 W=1e-05 AD=5e-12 AS=5e-12 PD=1e-06 PS=1e-06 NRD=0.0425 NRS=0.0425 $X=379575 $Y=56825 $D=41
M127 16 GNDA GNDA 16 pmos4 L=3.5e-07 W=1e-05 AD=5e-12 AS=5e-12 PD=1e-06 PS=1e-06 NRD=0.0425 NRS=0.0425 $X=380925 $Y=56825 $D=41
M128 GNDA GNDA 16 16 pmos4 L=3.5e-07 W=1e-05 AD=5e-12 AS=5e-12 PD=1e-06 PS=1e-06 NRD=0.0425 NRS=0.0425 $X=382275 $Y=56825 $D=41
M129 16 GNDA GNDA 16 pmos4 L=3.5e-07 W=1e-05 AD=8.5e-12 AS=5e-12 PD=1.17e-05 PS=1e-06 NRD=0.0425 NRS=0.0425 $X=383625 $Y=56825 $D=41
C130 GNDA IBIAS $[cpolya] $A=341.145 $P=73.9 $X=357900 $Y=-4900 $D=58
C131 GNDA VDDA $[cpolya] $A=2097.5 $P=183.9 $X=566550 $Y=135800 $D=58
X132 28 rpolyhc_CDNS_7807356271774 $T=561100 106350 0 0 $X=557100 $Y=102900
X133 33 rpolyhc_CDNS_7807356271774 $T=586700 125400 0 0 $X=582700 $Y=121950
X134 9 CVGA rpolyhc_CDNS_7807356271776 $T=469750 33350 0 180 $X=420250 $Y=12400
X135 20 9 rpolyhc_CDNS_7807356271776 $T=425600 52950 1 0 $X=420250 $Y=32000
X136 23 20 rpolyhc_CDNS_7807356271776 $T=469750 72550 0 180 $X=420250 $Y=51600
X137 21 23 rpolyhc_CDNS_7807356271776 $T=425600 92150 1 0 $X=420250 $Y=71200
X138 22 25 rpolyhc_CDNS_7807356271776 $T=474450 17050 0 0 $X=469100 $Y=12400
X139 25 24 rpolyhc_CDNS_7807356271776 $T=518600 36650 1 180 $X=469100 $Y=32000
X140 24 26 rpolyhc_CDNS_7807356271776 $T=474450 56250 0 0 $X=469100 $Y=51600
X141 26 21 rpolyhc_CDNS_7807356271776 $T=518600 75850 1 180 $X=469100 $Y=71200
X142 29 22 rpolyhc_CDNS_7807356271776 $T=567450 33350 0 180 $X=517950 $Y=12400
X143 27 29 rpolyhc_CDNS_7807356271776 $T=523300 52950 1 0 $X=517950 $Y=32000
X144 30 27 rpolyhc_CDNS_7807356271776 $T=567450 72550 0 180 $X=517950 $Y=51600
X145 32 30 rpolyhc_CDNS_7807356271776 $T=523300 92150 1 0 $X=517950 $Y=71200
X146 VOUT 34 rpolyhc_CDNS_7807356271776 $T=572150 17050 0 0 $X=566800 $Y=12400
X147 34 31 rpolyhc_CDNS_7807356271776 $T=616300 36650 1 180 $X=566800 $Y=32000
X148 31 35 rpolyhc_CDNS_7807356271776 $T=572150 56250 0 0 $X=566800 $Y=51600
X149 35 32 rpolyhc_CDNS_7807356271776 $T=616300 75850 1 180 $X=566800 $Y=71200
X150 9 S<0> 20 GNDA VDDA mux21 $T=414650 -9800 0 0 $X=415000 $Y=-9450
X151 20 S<1> 21 GNDA VDDA mux21 $T=454675 -9800 0 0 $X=455025 $Y=-9450
X152 21 S<2> 22 GNDA VDDA mux21 $T=505525 -9800 0 0 $X=505875 $Y=-9450
X153 22 S<3> VOUT GNDA VDDA mux21 $T=554425 -9800 0 0 $X=554775 $Y=-9450
X154 VOUT 12 cpolyc_CDNS_7807356271777 $T=431875 102700 0 0 $X=430525 $Y=101350
X155 VOUT 12 cpolyc_CDNS_7807356271777 $T=431875 143100 0 0 $X=430525 $Y=141750
X156 VOUT 12 cpolyc_CDNS_7807356271777 $T=473825 102700 0 0 $X=472475 $Y=101350
X157 VOUT 12 cpolyc_CDNS_7807356271777 $T=473825 143100 0 0 $X=472475 $Y=141750
X158 VOUT 12 cpolyc_CDNS_7807356271777 $T=515775 102700 0 0 $X=514425 $Y=101350
X159 VOUT 12 cpolyc_CDNS_7807356271777 $T=515775 143100 0 0 $X=514425 $Y=141750
X160 GNDA VOUT 17 GNDA nmos4_CDNS_7807356271761 $T=404250 34950 0 90 $X=395300 $Y=34550
X194 15 3 17 9 VIN ICV_11 $T=302025 139900 0 90 $X=295125 $Y=138700
X195 15 17 3 VIN 9 ICV_11 $T=302025 156700 0 90 $X=295125 $Y=155500
X196 15 17 17 VIN VIN ICV_11 $T=327225 139900 0 90 $X=320325 $Y=138700
X197 15 3 3 9 9 ICV_11 $T=327225 156700 0 90 $X=320325 $Y=155500
X198 15 17 3 VIN 9 ICV_11 $T=352425 139900 0 90 $X=345525 $Y=138700
X199 15 3 17 9 VIN ICV_11 $T=352425 156700 0 90 $X=345525 $Y=155500
X200 19 IBIAS IBIAS GNDA nmos4_CDNS_7807356271772 $T=318325 60350 0 90 $X=281375 $Y=59950
X201 18 14 IBIAS GNDA nmos4_CDNS_7807356271772 $T=355625 60350 0 90 $X=318675 $Y=59950
X204 GNDA 18 19 nmos4_CDNS_7807356271778 $T=312200 14450 0 90 $X=298250 $Y=14050
X205 GNDA 19 19 nmos4_CDNS_7807356271778 $T=312200 29250 0 90 $X=298250 $Y=28850
X206 GNDA 19 19 nmos4_CDNS_7807356271778 $T=326500 14450 0 90 $X=312550 $Y=14050
X207 GNDA 18 19 nmos4_CDNS_7807356271778 $T=326500 29250 0 90 $X=312550 $Y=28850
X297 VDDA ICV_14 $T=42025 2725 0 90 $X=24125 $Y=1525
X298 VDDA ICV_14 $T=42025 24525 0 90 $X=24125 $Y=23325
X299 VDDA ICV_14 $T=42025 46325 0 90 $X=24125 $Y=45125
X300 VDDA ICV_14 $T=42025 68125 0 90 $X=24125 $Y=66925
X301 VDDA ICV_14 $T=42025 89925 0 90 $X=24125 $Y=88725
X302 VDDA ICV_14 $T=42025 111725 0 90 $X=24125 $Y=110525
X303 VDDA ICV_14 $T=42025 133525 0 90 $X=24125 $Y=132325
X304 VDDA ICV_14 $T=42025 155325 0 90 $X=24125 $Y=154125
.ENDS
***************************************
.SUBCKT cpolyc_CDNS_7807356271715 1 2
** N=2 EP=2 IP=0 FDC=1
C0 1 2 $[cpolya] $A=3500 $P=240 $X=1800 $Y=1000 $D=58
.ENDS
***************************************
.SUBCKT ICV_15 1 2
*.CALIBRE ICV_CELL 9
** N=2 EP=2 IP=4 FDC=2
X0 1 2 cpolyc_CDNS_7807356271715 $T=0 0 0 0 $X=-1350 $Y=-1350
X1 1 2 cpolyc_CDNS_7807356271715 $T=76500 0 0 0 $X=75150 $Y=-1350
.ENDS
***************************************
.SUBCKT cpolyc_CDNS_7807356271717 1 2
** N=2 EP=2 IP=0 FDC=1
C0 1 2 $[cpolya] $A=4277 $P=261.6 $X=1800 $Y=1000 $D=58
.ENDS
***************************************
.SUBCKT cpolyc_CDNS_7807356271718 1 2
** N=2 EP=2 IP=0 FDC=1
C0 1 2 $[cpolya] $A=3466.12 $P=235.5 $X=1800 $Y=1000 $D=58
.ENDS
***************************************
.SUBCKT cpolyc_CDNS_7807356271723 1 2
** N=2 EP=2 IP=0 FDC=1
C0 1 2 $[cpolya] $A=11583 $P=430.5 $X=1800 $Y=1000 $D=58
.ENDS
***************************************
.SUBCKT nmos4_CDNS_7807356271711 1 2 3 4
** N=4 EP=4 IP=0 FDC=1
M0 2 3 1 4 nmos4 L=1e-06 W=2e-06 AD=1.7e-12 AS=1.7e-12 PD=3.7e-06 PS=3.7e-06 NRD=0.2125 NRS=0.2125 $X=0 $Y=850 $D=37
.ENDS
***************************************
.SUBCKT pmos4_CDNS_7807356271712 1 2 3 5
** N=5 EP=4 IP=0 FDC=1
M0 2 3 1 5 pmos4 L=1e-06 W=2e-06 AD=1.7e-12 AS=1.7e-12 PD=3.7e-06 PS=3.7e-06 NRD=0.2125 NRS=0.2125 $X=0 $Y=850 $D=41
.ENDS
***************************************
.SUBCKT INVX1 A vdd! gnd! Q
** N=4 EP=4 IP=0 FDC=2
M0 Q A gnd! gnd! nmos4 L=3.5e-07 W=4e-07 AD=5.7e-13 AS=1.45e-12 PD=2.8e-06 PS=6.5e-06 NRD=1.0625 NRS=1.0625 $X=1100 $Y=3450 $D=37
M1 Q A vdd! vdd! pmos4 L=3.5e-07 W=7e-07 AD=5.95e-13 AS=1.19e-12 PD=2.4e-06 PS=4.1e-06 NRD=0.607143 NRS=0.607143 $X=1250 $Y=6400 $D=41
.ENDS
***************************************
.SUBCKT P1_C_CDNS_78073562717101
** N=2 EP=0 IP=0 FDC=0
.ENDS
***************************************
.SUBCKT ND_C_CDNS_78073562717113
** N=2 EP=0 IP=0 FDC=0
.ENDS
***************************************
.SUBCKT P1_C_CDNS_7807356271789
** N=2 EP=0 IP=0 FDC=0
.ENDS
***************************************
.SUBCKT pmos4_CDNS_7807356271721 1 2 3
** N=4 EP=3 IP=0 FDC=20
M0 2 3 1 1 pmos4 L=3.5e-07 W=1.5e-05 AD=7.5e-12 AS=1.275e-11 PD=1e-06 PS=1.67e-05 NRD=0.0283333 NRS=0.0283333 $X=0 $Y=850 $D=41
M1 1 3 2 1 pmos4 L=3.5e-07 W=1.5e-05 AD=7.5e-12 AS=7.5e-12 PD=1e-06 PS=1e-06 NRD=0.0283333 NRS=0.0283333 $X=0 $Y=2200 $D=41
M2 2 3 1 1 pmos4 L=3.5e-07 W=1.5e-05 AD=7.5e-12 AS=7.5e-12 PD=1e-06 PS=1e-06 NRD=0.0283333 NRS=0.0283333 $X=0 $Y=3550 $D=41
M3 1 3 2 1 pmos4 L=3.5e-07 W=1.5e-05 AD=7.5e-12 AS=7.5e-12 PD=1e-06 PS=1e-06 NRD=0.0283333 NRS=0.0283333 $X=0 $Y=4900 $D=41
M4 2 3 1 1 pmos4 L=3.5e-07 W=1.5e-05 AD=7.5e-12 AS=7.5e-12 PD=1e-06 PS=1e-06 NRD=0.0283333 NRS=0.0283333 $X=0 $Y=6250 $D=41
M5 1 3 2 1 pmos4 L=3.5e-07 W=1.5e-05 AD=7.5e-12 AS=7.5e-12 PD=1e-06 PS=1e-06 NRD=0.0283333 NRS=0.0283333 $X=0 $Y=7600 $D=41
M6 2 3 1 1 pmos4 L=3.5e-07 W=1.5e-05 AD=7.5e-12 AS=7.5e-12 PD=1e-06 PS=1e-06 NRD=0.0283333 NRS=0.0283333 $X=0 $Y=8950 $D=41
M7 1 3 2 1 pmos4 L=3.5e-07 W=1.5e-05 AD=7.5e-12 AS=7.5e-12 PD=1e-06 PS=1e-06 NRD=0.0283333 NRS=0.0283333 $X=0 $Y=10300 $D=41
M8 2 3 1 1 pmos4 L=3.5e-07 W=1.5e-05 AD=7.5e-12 AS=7.5e-12 PD=1e-06 PS=1e-06 NRD=0.0283333 NRS=0.0283333 $X=0 $Y=11650 $D=41
M9 1 3 2 1 pmos4 L=3.5e-07 W=1.5e-05 AD=7.5e-12 AS=7.5e-12 PD=1e-06 PS=1e-06 NRD=0.0283333 NRS=0.0283333 $X=0 $Y=13000 $D=41
M10 2 3 1 1 pmos4 L=3.5e-07 W=1.5e-05 AD=7.5e-12 AS=7.5e-12 PD=1e-06 PS=1e-06 NRD=0.0283333 NRS=0.0283333 $X=0 $Y=14350 $D=41
M11 1 3 2 1 pmos4 L=3.5e-07 W=1.5e-05 AD=7.5e-12 AS=7.5e-12 PD=1e-06 PS=1e-06 NRD=0.0283333 NRS=0.0283333 $X=0 $Y=15700 $D=41
M12 2 3 1 1 pmos4 L=3.5e-07 W=1.5e-05 AD=7.5e-12 AS=7.5e-12 PD=1e-06 PS=1e-06 NRD=0.0283333 NRS=0.0283333 $X=0 $Y=17050 $D=41
M13 1 3 2 1 pmos4 L=3.5e-07 W=1.5e-05 AD=7.5e-12 AS=7.5e-12 PD=1e-06 PS=1e-06 NRD=0.0283333 NRS=0.0283333 $X=0 $Y=18400 $D=41
M14 2 3 1 1 pmos4 L=3.5e-07 W=1.5e-05 AD=7.5e-12 AS=7.5e-12 PD=1e-06 PS=1e-06 NRD=0.0283333 NRS=0.0283333 $X=0 $Y=19750 $D=41
M15 1 3 2 1 pmos4 L=3.5e-07 W=1.5e-05 AD=7.5e-12 AS=7.5e-12 PD=1e-06 PS=1e-06 NRD=0.0283333 NRS=0.0283333 $X=0 $Y=21100 $D=41
M16 2 3 1 1 pmos4 L=3.5e-07 W=1.5e-05 AD=7.5e-12 AS=7.5e-12 PD=1e-06 PS=1e-06 NRD=0.0283333 NRS=0.0283333 $X=0 $Y=22450 $D=41
M17 1 3 2 1 pmos4 L=3.5e-07 W=1.5e-05 AD=7.5e-12 AS=7.5e-12 PD=1e-06 PS=1e-06 NRD=0.0283333 NRS=0.0283333 $X=0 $Y=23800 $D=41
M18 2 3 1 1 pmos4 L=3.5e-07 W=1.5e-05 AD=7.5e-12 AS=7.5e-12 PD=1e-06 PS=1e-06 NRD=0.0283333 NRS=0.0283333 $X=0 $Y=25150 $D=41
M19 1 3 2 1 pmos4 L=3.5e-07 W=1.5e-05 AD=1.275e-11 AS=7.5e-12 PD=1.67e-05 PS=1e-06 NRD=0.0283333 NRS=0.0283333 $X=0 $Y=26500 $D=41
.ENDS
***************************************
.SUBCKT PD_C_CDNS_78073562717132
** N=1 EP=0 IP=0 FDC=0
.ENDS
***************************************
.SUBCKT nmos4_CDNS_7807356271710
** N=4 EP=0 IP=0 FDC=0
.ENDS
***************************************
.SUBCKT ICV_16
** N=6 EP=0 IP=8 FDC=0
.ENDS
***************************************
.SUBCKT ICV_17
** N=10 EP=0 IP=12 FDC=0
.ENDS
***************************************
.SUBCKT ICV_18
** N=18 EP=0 IP=20 FDC=0
.ENDS
***************************************
.SUBCKT ICV_19 3 24 25 26 27 28 29 30 31 32 33 34 35 36 37 38 39 42
** N=42 EP=18 IP=52 FDC=10
M0 3 3 3 42 nmos4 L=2e-05 W=2e-06 AD=1.7e-12 AS=1.7e-12 PD=3.7e-06 PS=3.7e-06 NRD=0.2125 NRS=0.2125 $X=0 $Y=850 $D=38
M1 3 3 3 42 nmos4 L=2e-05 W=2e-06 AD=1.7e-12 AS=1.7e-12 PD=3.7e-06 PS=3.7e-06 NRD=0.2125 NRS=0.2125 $X=68250 $Y=850 $D=38
M2 25 3 24 42 nmos4 L=2e-05 W=2e-06 AD=1.7e-12 AS=1.7e-12 PD=3.7e-06 PS=3.7e-06 NRD=0.2125 NRS=0.2125 $X=22750 $Y=850 $D=37
M3 27 3 26 42 nmos4 L=2e-05 W=2e-06 AD=1.7e-12 AS=1.7e-12 PD=3.7e-06 PS=3.7e-06 NRD=0.2125 NRS=0.2125 $X=26000 $Y=850 $D=37
M4 29 3 28 42 nmos4 L=2e-05 W=2e-06 AD=1.7e-12 AS=1.7e-12 PD=3.7e-06 PS=3.7e-06 NRD=0.2125 NRS=0.2125 $X=29250 $Y=850 $D=37
M5 31 3 30 42 nmos4 L=2e-05 W=2e-06 AD=1.7e-12 AS=1.7e-12 PD=3.7e-06 PS=3.7e-06 NRD=0.2125 NRS=0.2125 $X=32500 $Y=850 $D=37
M6 33 3 32 42 nmos4 L=2e-05 W=2e-06 AD=1.7e-12 AS=1.7e-12 PD=3.7e-06 PS=3.7e-06 NRD=0.2125 NRS=0.2125 $X=35750 $Y=850 $D=37
M7 35 3 34 42 nmos4 L=2e-05 W=2e-06 AD=1.7e-12 AS=1.7e-12 PD=3.7e-06 PS=3.7e-06 NRD=0.2125 NRS=0.2125 $X=39000 $Y=850 $D=37
M8 37 3 36 42 nmos4 L=2e-05 W=2e-06 AD=1.7e-12 AS=1.7e-12 PD=3.7e-06 PS=3.7e-06 NRD=0.2125 NRS=0.2125 $X=42250 $Y=850 $D=37
M9 39 3 38 42 nmos4 L=2e-05 W=2e-06 AD=1.7e-12 AS=1.7e-12 PD=3.7e-06 PS=3.7e-06 NRD=0.2125 NRS=0.2125 $X=45500 $Y=850 $D=37
.ENDS
***************************************
.SUBCKT pmos4_CDNS_7807356271722
** N=4 EP=0 IP=0 FDC=0
.ENDS
***************************************
.SUBCKT PD_C_CDNS_78073562717130
** N=1 EP=0 IP=0 FDC=0
.ENDS
***************************************
.SUBCKT ICV_20 1 3 5
** N=6 EP=3 IP=8 FDC=1
M0 3 5 1 1 pmos4 L=5e-06 W=6e-06 AD=5.1e-12 AS=5.1e-12 PD=7.7e-06 PS=7.7e-06 NRD=0.0708333 NRS=0.0708333 $X=0 $Y=8150 $D=41
.ENDS
***************************************
.SUBCKT ICV_21 1 3 4 5 7
** N=8 EP=5 IP=12 FDC=3
M0 4 7 1 1 pmos4 L=5e-06 W=6e-06 AD=5.1e-12 AS=5.1e-12 PD=7.7e-06 PS=7.7e-06 NRD=0.0708333 NRS=0.0708333 $X=0 $Y=15450 $D=41
X1 1 3 7 ICV_20 $T=0 0 0 0 $X=-1200 $Y=-1200
X2 1 5 7 ICV_20 $T=0 14600 0 0 $X=-1200 $Y=13400
.ENDS
***************************************
.SUBCKT P1_C_CDNS_7807356271794
** N=2 EP=0 IP=0 FDC=0
.ENDS
***************************************
.SUBCKT nmos4_CDNS_7807356271720 1
** N=1 EP=1 IP=0 FDC=1
M0 1 1 1 1 nmos4 L=4e-06 W=2e-06 AD=1.7e-12 AS=1.7e-12 PD=3.7e-06 PS=3.7e-06 NRD=0.2125 NRS=0.2125 $X=0 $Y=850 $D=38
.ENDS
***************************************
.SUBCKT ICV_22 1
*.CALIBRE ICV_CELL 9
** N=1 EP=1 IP=2 FDC=2
X0 1 nmos4_CDNS_7807356271720 $T=0 0 0 0 $X=-400 $Y=-250
X1 1 nmos4_CDNS_7807356271720 $T=3250 0 0 0 $X=2850 $Y=-250
.ENDS
***************************************
.SUBCKT nmos4_CDNS_7807356271719
** N=4 EP=0 IP=0 FDC=0
.ENDS
***************************************
.SUBCKT ICV_23
** N=6 EP=0 IP=8 FDC=0
.ENDS
***************************************
.SUBCKT ICV_24 1
*.CALIBRE ICV_CELL 9
** N=1 EP=1 IP=2 FDC=4
X0 1 ICV_22 $T=0 0 0 0 $X=-400 $Y=-250
X1 1 ICV_22 $T=6500 0 0 0 $X=6100 $Y=-250
.ENDS
***************************************
.SUBCKT ICV_25
** N=10 EP=0 IP=12 FDC=0
.ENDS
***************************************
.SUBCKT nmos4_CDNS_7807356271714 1 2 3 4
** N=4 EP=4 IP=0 FDC=2
M0 2 3 1 4 nmos4 L=4e-06 W=1e-05 AD=5e-12 AS=8.5e-12 PD=1e-06 PS=1.17e-05 NRD=0.0425 NRS=0.0425 $X=0 $Y=850 $D=37
M1 1 3 2 4 nmos4 L=4e-06 W=1e-05 AD=8.5e-12 AS=5e-12 PD=1.17e-05 PS=1e-06 NRD=0.0425 NRS=0.0425 $X=0 $Y=5850 $D=37
.ENDS
***************************************
.SUBCKT ICV_26 1 2 3 4 5 6 7 8 9 10 11 12
** N=12 EP=12 IP=20 FDC=8
M0 1 1 1 12 nmos4 L=1e-05 W=2e-06 AD=1.7e-12 AS=1.7e-12 PD=3.7e-06 PS=3.7e-06 NRD=0.2125 NRS=0.2125 $X=0 $Y=850 $D=38
M1 3 1 2 12 nmos4 L=1e-05 W=2e-06 AD=1.7e-12 AS=1.7e-12 PD=3.7e-06 PS=3.7e-06 NRD=0.2125 NRS=0.2125 $X=3250 $Y=850 $D=37
M2 3 1 2 12 nmos4 L=1e-05 W=2e-06 AD=1.7e-12 AS=1.7e-12 PD=3.7e-06 PS=3.7e-06 NRD=0.2125 NRS=0.2125 $X=6500 $Y=850 $D=37
M3 5 1 4 12 nmos4 L=1e-05 W=2e-06 AD=1.7e-12 AS=1.7e-12 PD=3.7e-06 PS=3.7e-06 NRD=0.2125 NRS=0.2125 $X=9750 $Y=850 $D=37
M4 7 1 6 12 nmos4 L=1e-05 W=2e-06 AD=1.7e-12 AS=1.7e-12 PD=3.7e-06 PS=3.7e-06 NRD=0.2125 NRS=0.2125 $X=13000 $Y=850 $D=37
M5 9 1 8 12 nmos4 L=1e-05 W=2e-06 AD=1.7e-12 AS=1.7e-12 PD=3.7e-06 PS=3.7e-06 NRD=0.2125 NRS=0.2125 $X=16250 $Y=850 $D=37
M6 9 1 8 12 nmos4 L=1e-05 W=2e-06 AD=1.7e-12 AS=1.7e-12 PD=3.7e-06 PS=3.7e-06 NRD=0.2125 NRS=0.2125 $X=19500 $Y=850 $D=37
M7 11 1 10 12 nmos4 L=1e-05 W=2e-06 AD=1.7e-12 AS=1.7e-12 PD=3.7e-06 PS=3.7e-06 NRD=0.2125 NRS=0.2125 $X=22750 $Y=850 $D=37
.ENDS
***************************************
.SUBCKT Gm_C_filter 1 2 VDDA 4 5 BIAS 7 OUT S<0> 10 11 12 GNDA INP INN S<1> S<2>
** N=171 EP=17 IP=811 FDC=464
R0 2 1 L=0.00194965 W=2e-06 $[rpolyh] $X=284375 $Y=-260100 $D=18
D1 GNDA VDDA p_nwd AREA=6385.26 PJ=361 $X=30275 $Y=-98150 $D=87
D2 GNDA 2 p_nwd AREA=609 PJ=104.8 $X=190800 $Y=-78200 $D=87
D3 GNDA 1 p_nwd AREA=599.43 PJ=103.7 $X=191400 $Y=-102300 $D=87
D4 GNDA 1 p_nwd AREA=598.56 PJ=103.6 $X=230950 $Y=-78200 $D=87
D5 GNDA 2 p_nwd AREA=595.08 PJ=103.2 $X=231200 $Y=-102300 $D=87
D6 GNDA VDDA p_nwd AREA=1316.46 PJ=148.1 $X=282925 $Y=-76700 $D=87
D7 GNDA VDDA p_nwd AREA=97.8125 PJ=43.8 $X=333550 $Y=-60700 $D=87
M8 20 20 20 GNDA nmos4 L=1e-05 W=2e-06 AD=1.7e-12 AS=1.7e-12 PD=3.7e-06 PS=3.7e-06 NRD=0.2125 NRS=0.2125 $X=65625 $Y=-181350 $D=38
M9 20 20 20 GNDA nmos4 L=1e-05 W=2e-06 AD=1.7e-12 AS=1.7e-12 PD=3.7e-06 PS=3.7e-06 NRD=0.2125 NRS=0.2125 $X=68875 $Y=-181350 $D=38
M10 20 20 20 GNDA nmos4 L=1e-05 W=2e-06 AD=1.7e-12 AS=1.7e-12 PD=3.7e-06 PS=3.7e-06 NRD=0.2125 NRS=0.2125 $X=72125 $Y=-181350 $D=38
M11 20 20 20 GNDA nmos4 L=1e-05 W=2e-06 AD=1.7e-12 AS=1.7e-12 PD=3.7e-06 PS=3.7e-06 NRD=0.2125 NRS=0.2125 $X=75375 $Y=-181350 $D=38
M12 20 20 20 GNDA nmos4 L=1e-05 W=2e-06 AD=1.7e-12 AS=1.7e-12 PD=3.7e-06 PS=3.7e-06 NRD=0.2125 NRS=0.2125 $X=78625 $Y=-212950 $D=38
M13 20 20 20 GNDA nmos4 L=1e-05 W=2e-06 AD=1.7e-12 AS=1.7e-12 PD=3.7e-06 PS=3.7e-06 NRD=0.2125 NRS=0.2125 $X=78625 $Y=-197150 $D=38
M14 20 20 20 GNDA nmos4 L=1e-05 W=2e-06 AD=1.7e-12 AS=1.7e-12 PD=3.7e-06 PS=3.7e-06 NRD=0.2125 NRS=0.2125 $X=78625 $Y=-181350 $D=38
M15 20 20 20 GNDA nmos4 L=1e-05 W=2e-06 AD=1.7e-12 AS=1.7e-12 PD=3.7e-06 PS=3.7e-06 NRD=0.2125 NRS=0.2125 $X=78625 $Y=-165550 $D=38
M16 4 4 4 GNDA nmos4 L=2e-05 W=2e-06 AD=1.7e-12 AS=1.7e-12 PD=3.7e-06 PS=3.7e-06 NRD=0.2125 NRS=0.2125 $X=115250 $Y=-259200 $D=38
M17 4 4 4 GNDA nmos4 L=2e-05 W=2e-06 AD=1.7e-12 AS=1.7e-12 PD=3.7e-06 PS=3.7e-06 NRD=0.2125 NRS=0.2125 $X=118500 $Y=-259200 $D=38
M18 4 4 4 GNDA nmos4 L=2e-05 W=2e-06 AD=1.7e-12 AS=1.7e-12 PD=3.7e-06 PS=3.7e-06 NRD=0.2125 NRS=0.2125 $X=121750 $Y=-259200 $D=38
M19 4 4 4 GNDA nmos4 L=2e-05 W=2e-06 AD=1.7e-12 AS=1.7e-12 PD=3.7e-06 PS=3.7e-06 NRD=0.2125 NRS=0.2125 $X=125000 $Y=-259200 $D=38
M20 4 4 4 GNDA nmos4 L=2e-05 W=2e-06 AD=1.7e-12 AS=1.7e-12 PD=3.7e-06 PS=3.7e-06 NRD=0.2125 NRS=0.2125 $X=128250 $Y=-259200 $D=38
M21 4 4 4 GNDA nmos4 L=2e-05 W=2e-06 AD=1.7e-12 AS=1.7e-12 PD=3.7e-06 PS=3.7e-06 NRD=0.2125 NRS=0.2125 $X=131500 $Y=-259200 $D=38
M22 4 4 4 GNDA nmos4 L=2e-05 W=2e-06 AD=1.7e-12 AS=1.7e-12 PD=3.7e-06 PS=3.7e-06 NRD=0.2125 NRS=0.2125 $X=160750 $Y=-259200 $D=38
M23 4 4 4 GNDA nmos4 L=2e-05 W=2e-06 AD=1.7e-12 AS=1.7e-12 PD=3.7e-06 PS=3.7e-06 NRD=0.2125 NRS=0.2125 $X=164000 $Y=-259200 $D=38
M24 4 4 4 GNDA nmos4 L=2e-05 W=2e-06 AD=1.7e-12 AS=1.7e-12 PD=3.7e-06 PS=3.7e-06 NRD=0.2125 NRS=0.2125 $X=167250 $Y=-259200 $D=38
M25 4 4 4 GNDA nmos4 L=2e-05 W=2e-06 AD=1.7e-12 AS=1.7e-12 PD=3.7e-06 PS=3.7e-06 NRD=0.2125 NRS=0.2125 $X=170500 $Y=-259200 $D=38
M26 4 4 4 GNDA nmos4 L=2e-05 W=2e-06 AD=1.7e-12 AS=1.7e-12 PD=3.7e-06 PS=3.7e-06 NRD=0.2125 NRS=0.2125 $X=173750 $Y=-259200 $D=38
M27 4 4 4 GNDA nmos4 L=2e-05 W=2e-06 AD=1.7e-12 AS=1.7e-12 PD=3.7e-06 PS=3.7e-06 NRD=0.2125 NRS=0.2125 $X=177000 $Y=-259200 $D=38
M28 5 5 5 GNDA nmos4 L=2e-05 W=2e-06 AD=1.7e-12 AS=1.7e-12 PD=3.7e-06 PS=3.7e-06 NRD=0.2125 NRS=0.2125 $X=204025 $Y=-258400 $D=38
M29 5 5 5 GNDA nmos4 L=2e-05 W=2e-06 AD=1.7e-12 AS=1.7e-12 PD=3.7e-06 PS=3.7e-06 NRD=0.2125 NRS=0.2125 $X=207275 $Y=-258400 $D=38
M30 5 5 5 GNDA nmos4 L=2e-05 W=2e-06 AD=1.7e-12 AS=1.7e-12 PD=3.7e-06 PS=3.7e-06 NRD=0.2125 NRS=0.2125 $X=210525 $Y=-258400 $D=38
M31 5 5 5 GNDA nmos4 L=2e-05 W=2e-06 AD=1.7e-12 AS=1.7e-12 PD=3.7e-06 PS=3.7e-06 NRD=0.2125 NRS=0.2125 $X=213775 $Y=-258400 $D=38
M32 5 5 5 GNDA nmos4 L=2e-05 W=2e-06 AD=1.7e-12 AS=1.7e-12 PD=3.7e-06 PS=3.7e-06 NRD=0.2125 NRS=0.2125 $X=217025 $Y=-258400 $D=38
M33 5 5 5 GNDA nmos4 L=2e-05 W=2e-06 AD=1.7e-12 AS=1.7e-12 PD=3.7e-06 PS=3.7e-06 NRD=0.2125 NRS=0.2125 $X=220275 $Y=-258400 $D=38
M34 5 5 5 GNDA nmos4 L=2e-05 W=2e-06 AD=1.7e-12 AS=1.7e-12 PD=3.7e-06 PS=3.7e-06 NRD=0.2125 NRS=0.2125 $X=249525 $Y=-258400 $D=38
M35 5 5 5 GNDA nmos4 L=2e-05 W=2e-06 AD=1.7e-12 AS=1.7e-12 PD=3.7e-06 PS=3.7e-06 NRD=0.2125 NRS=0.2125 $X=252775 $Y=-258400 $D=38
M36 5 5 5 GNDA nmos4 L=2e-05 W=2e-06 AD=1.7e-12 AS=1.7e-12 PD=3.7e-06 PS=3.7e-06 NRD=0.2125 NRS=0.2125 $X=256025 $Y=-258400 $D=38
M37 5 5 5 GNDA nmos4 L=2e-05 W=2e-06 AD=1.7e-12 AS=1.7e-12 PD=3.7e-06 PS=3.7e-06 NRD=0.2125 NRS=0.2125 $X=259275 $Y=-258400 $D=38
M38 5 5 5 GNDA nmos4 L=2e-05 W=2e-06 AD=1.7e-12 AS=1.7e-12 PD=3.7e-06 PS=3.7e-06 NRD=0.2125 NRS=0.2125 $X=262525 $Y=-258400 $D=38
M39 5 5 5 GNDA nmos4 L=2e-05 W=2e-06 AD=1.7e-12 AS=1.7e-12 PD=3.7e-06 PS=3.7e-06 NRD=0.2125 NRS=0.2125 $X=265775 $Y=-258400 $D=38
M40 30 20 34 GNDA nmos4 L=1e-05 W=2e-06 AD=1.7e-12 AS=1.7e-12 PD=3.7e-06 PS=3.7e-06 NRD=0.2125 NRS=0.2125 $X=62375 $Y=-212950 $D=37
M41 31 20 35 GNDA nmos4 L=1e-05 W=2e-06 AD=1.7e-12 AS=1.7e-12 PD=3.7e-06 PS=3.7e-06 NRD=0.2125 NRS=0.2125 $X=62375 $Y=-197150 $D=37
M42 20 20 32 GNDA nmos4 L=1e-05 W=2e-06 AD=1.7e-12 AS=1.7e-12 PD=3.7e-06 PS=3.7e-06 NRD=0.2125 NRS=0.2125 $X=62375 $Y=-181350 $D=37
M43 33 20 36 GNDA nmos4 L=1e-05 W=2e-06 AD=1.7e-12 AS=1.7e-12 PD=3.7e-06 PS=3.7e-06 NRD=0.2125 NRS=0.2125 $X=62375 $Y=-165550 $D=37
M44 30 20 34 GNDA nmos4 L=1e-05 W=2e-06 AD=1.7e-12 AS=1.7e-12 PD=3.7e-06 PS=3.7e-06 NRD=0.2125 NRS=0.2125 $X=65625 $Y=-212950 $D=37
M45 31 20 35 GNDA nmos4 L=1e-05 W=2e-06 AD=1.7e-12 AS=1.7e-12 PD=3.7e-06 PS=3.7e-06 NRD=0.2125 NRS=0.2125 $X=65625 $Y=-197150 $D=37
M46 33 20 36 GNDA nmos4 L=1e-05 W=2e-06 AD=1.7e-12 AS=1.7e-12 PD=3.7e-06 PS=3.7e-06 NRD=0.2125 NRS=0.2125 $X=65625 $Y=-165550 $D=37
M47 34 20 GNDA GNDA nmos4 L=1e-05 W=2e-06 AD=1.7e-12 AS=1.7e-12 PD=3.7e-06 PS=3.7e-06 NRD=0.2125 NRS=0.2125 $X=68875 $Y=-212950 $D=37
M48 35 20 GNDA GNDA nmos4 L=1e-05 W=2e-06 AD=1.7e-12 AS=1.7e-12 PD=3.7e-06 PS=3.7e-06 NRD=0.2125 NRS=0.2125 $X=68875 $Y=-197150 $D=37
M49 36 20 GNDA GNDA nmos4 L=1e-05 W=2e-06 AD=1.7e-12 AS=1.7e-12 PD=3.7e-06 PS=3.7e-06 NRD=0.2125 NRS=0.2125 $X=68875 $Y=-165550 $D=37
M50 34 20 GNDA GNDA nmos4 L=1e-05 W=2e-06 AD=1.7e-12 AS=1.7e-12 PD=3.7e-06 PS=3.7e-06 NRD=0.2125 NRS=0.2125 $X=72125 $Y=-212950 $D=37
M51 35 20 GNDA GNDA nmos4 L=1e-05 W=2e-06 AD=1.7e-12 AS=1.7e-12 PD=3.7e-06 PS=3.7e-06 NRD=0.2125 NRS=0.2125 $X=72125 $Y=-197150 $D=37
M52 36 20 GNDA GNDA nmos4 L=1e-05 W=2e-06 AD=1.7e-12 AS=1.7e-12 PD=3.7e-06 PS=3.7e-06 NRD=0.2125 NRS=0.2125 $X=72125 $Y=-165550 $D=37
M53 34 20 GNDA GNDA nmos4 L=1e-05 W=2e-06 AD=1.7e-12 AS=1.7e-12 PD=3.7e-06 PS=3.7e-06 NRD=0.2125 NRS=0.2125 $X=75375 $Y=-212950 $D=37
M54 35 20 GNDA GNDA nmos4 L=1e-05 W=2e-06 AD=1.7e-12 AS=1.7e-12 PD=3.7e-06 PS=3.7e-06 NRD=0.2125 NRS=0.2125 $X=75375 $Y=-197150 $D=37
M55 36 20 GNDA GNDA nmos4 L=1e-05 W=2e-06 AD=1.7e-12 AS=1.7e-12 PD=3.7e-06 PS=3.7e-06 NRD=0.2125 NRS=0.2125 $X=75375 $Y=-165550 $D=37
M56 37 4 GNDA GNDA nmos4 L=2e-05 W=2e-06 AD=1.7e-12 AS=1.7e-12 PD=3.7e-06 PS=3.7e-06 NRD=0.2125 NRS=0.2125 $X=115250 $Y=-232600 $D=37
M57 38 4 37 GNDA nmos4 L=2e-05 W=2e-06 AD=1.7e-12 AS=1.7e-12 PD=3.7e-06 PS=3.7e-06 NRD=0.2125 NRS=0.2125 $X=115250 $Y=-206800 $D=37
M58 39 4 38 GNDA nmos4 L=2e-05 W=2e-06 AD=1.7e-12 AS=1.7e-12 PD=3.7e-06 PS=3.7e-06 NRD=0.2125 NRS=0.2125 $X=115250 $Y=-181000 $D=37
M59 1 4 39 GNDA nmos4 L=2e-05 W=2e-06 AD=1.7e-12 AS=1.7e-12 PD=3.7e-06 PS=3.7e-06 NRD=0.2125 NRS=0.2125 $X=115250 $Y=-155200 $D=37
M60 40 4 GNDA GNDA nmos4 L=2e-05 W=2e-06 AD=1.7e-12 AS=1.7e-12 PD=3.7e-06 PS=3.7e-06 NRD=0.2125 NRS=0.2125 $X=118500 $Y=-232600 $D=37
M61 41 4 40 GNDA nmos4 L=2e-05 W=2e-06 AD=1.7e-12 AS=1.7e-12 PD=3.7e-06 PS=3.7e-06 NRD=0.2125 NRS=0.2125 $X=118500 $Y=-206800 $D=37
M62 42 4 41 GNDA nmos4 L=2e-05 W=2e-06 AD=1.7e-12 AS=1.7e-12 PD=3.7e-06 PS=3.7e-06 NRD=0.2125 NRS=0.2125 $X=118500 $Y=-181000 $D=37
M63 1 4 42 GNDA nmos4 L=2e-05 W=2e-06 AD=1.7e-12 AS=1.7e-12 PD=3.7e-06 PS=3.7e-06 NRD=0.2125 NRS=0.2125 $X=118500 $Y=-155200 $D=37
M64 43 4 GNDA GNDA nmos4 L=2e-05 W=2e-06 AD=1.7e-12 AS=1.7e-12 PD=3.7e-06 PS=3.7e-06 NRD=0.2125 NRS=0.2125 $X=121750 $Y=-232600 $D=37
M65 44 4 43 GNDA nmos4 L=2e-05 W=2e-06 AD=1.7e-12 AS=1.7e-12 PD=3.7e-06 PS=3.7e-06 NRD=0.2125 NRS=0.2125 $X=121750 $Y=-206800 $D=37
M66 45 4 44 GNDA nmos4 L=2e-05 W=2e-06 AD=1.7e-12 AS=1.7e-12 PD=3.7e-06 PS=3.7e-06 NRD=0.2125 NRS=0.2125 $X=121750 $Y=-181000 $D=37
M67 1 4 45 GNDA nmos4 L=2e-05 W=2e-06 AD=1.7e-12 AS=1.7e-12 PD=3.7e-06 PS=3.7e-06 NRD=0.2125 NRS=0.2125 $X=121750 $Y=-155200 $D=37
M68 46 4 GNDA GNDA nmos4 L=2e-05 W=2e-06 AD=1.7e-12 AS=1.7e-12 PD=3.7e-06 PS=3.7e-06 NRD=0.2125 NRS=0.2125 $X=125000 $Y=-232600 $D=37
M69 47 4 46 GNDA nmos4 L=2e-05 W=2e-06 AD=1.7e-12 AS=1.7e-12 PD=3.7e-06 PS=3.7e-06 NRD=0.2125 NRS=0.2125 $X=125000 $Y=-206800 $D=37
M70 48 4 47 GNDA nmos4 L=2e-05 W=2e-06 AD=1.7e-12 AS=1.7e-12 PD=3.7e-06 PS=3.7e-06 NRD=0.2125 NRS=0.2125 $X=125000 $Y=-181000 $D=37
M71 1 4 48 GNDA nmos4 L=2e-05 W=2e-06 AD=1.7e-12 AS=1.7e-12 PD=3.7e-06 PS=3.7e-06 NRD=0.2125 NRS=0.2125 $X=125000 $Y=-155200 $D=37
M72 49 4 GNDA GNDA nmos4 L=2e-05 W=2e-06 AD=1.7e-12 AS=1.7e-12 PD=3.7e-06 PS=3.7e-06 NRD=0.2125 NRS=0.2125 $X=128250 $Y=-232600 $D=37
M73 50 4 49 GNDA nmos4 L=2e-05 W=2e-06 AD=1.7e-12 AS=1.7e-12 PD=3.7e-06 PS=3.7e-06 NRD=0.2125 NRS=0.2125 $X=128250 $Y=-206800 $D=37
M74 51 4 50 GNDA nmos4 L=2e-05 W=2e-06 AD=1.7e-12 AS=1.7e-12 PD=3.7e-06 PS=3.7e-06 NRD=0.2125 NRS=0.2125 $X=128250 $Y=-181000 $D=37
M75 1 4 51 GNDA nmos4 L=2e-05 W=2e-06 AD=1.7e-12 AS=1.7e-12 PD=3.7e-06 PS=3.7e-06 NRD=0.2125 NRS=0.2125 $X=128250 $Y=-155200 $D=37
M76 52 4 GNDA GNDA nmos4 L=2e-05 W=2e-06 AD=1.7e-12 AS=1.7e-12 PD=3.7e-06 PS=3.7e-06 NRD=0.2125 NRS=0.2125 $X=131500 $Y=-232600 $D=37
M77 53 4 52 GNDA nmos4 L=2e-05 W=2e-06 AD=1.7e-12 AS=1.7e-12 PD=3.7e-06 PS=3.7e-06 NRD=0.2125 NRS=0.2125 $X=131500 $Y=-206800 $D=37
M78 54 4 53 GNDA nmos4 L=2e-05 W=2e-06 AD=1.7e-12 AS=1.7e-12 PD=3.7e-06 PS=3.7e-06 NRD=0.2125 NRS=0.2125 $X=131500 $Y=-181000 $D=37
M79 1 4 54 GNDA nmos4 L=2e-05 W=2e-06 AD=1.7e-12 AS=1.7e-12 PD=3.7e-06 PS=3.7e-06 NRD=0.2125 NRS=0.2125 $X=131500 $Y=-155200 $D=37
M80 86 4 GNDA GNDA nmos4 L=2e-05 W=2e-06 AD=1.7e-12 AS=1.7e-12 PD=3.7e-06 PS=3.7e-06 NRD=0.2125 NRS=0.2125 $X=160750 $Y=-232600 $D=37
M81 87 4 86 GNDA nmos4 L=2e-05 W=2e-06 AD=1.7e-12 AS=1.7e-12 PD=3.7e-06 PS=3.7e-06 NRD=0.2125 NRS=0.2125 $X=160750 $Y=-206800 $D=37
M82 88 4 87 GNDA nmos4 L=2e-05 W=2e-06 AD=1.7e-12 AS=1.7e-12 PD=3.7e-06 PS=3.7e-06 NRD=0.2125 NRS=0.2125 $X=160750 $Y=-181000 $D=37
M83 1 4 88 GNDA nmos4 L=2e-05 W=2e-06 AD=1.7e-12 AS=1.7e-12 PD=3.7e-06 PS=3.7e-06 NRD=0.2125 NRS=0.2125 $X=160750 $Y=-155200 $D=37
M84 89 4 GNDA GNDA nmos4 L=2e-05 W=2e-06 AD=1.7e-12 AS=1.7e-12 PD=3.7e-06 PS=3.7e-06 NRD=0.2125 NRS=0.2125 $X=164000 $Y=-232600 $D=37
M85 90 4 89 GNDA nmos4 L=2e-05 W=2e-06 AD=1.7e-12 AS=1.7e-12 PD=3.7e-06 PS=3.7e-06 NRD=0.2125 NRS=0.2125 $X=164000 $Y=-206800 $D=37
M86 91 4 90 GNDA nmos4 L=2e-05 W=2e-06 AD=1.7e-12 AS=1.7e-12 PD=3.7e-06 PS=3.7e-06 NRD=0.2125 NRS=0.2125 $X=164000 $Y=-181000 $D=37
M87 1 4 91 GNDA nmos4 L=2e-05 W=2e-06 AD=1.7e-12 AS=1.7e-12 PD=3.7e-06 PS=3.7e-06 NRD=0.2125 NRS=0.2125 $X=164000 $Y=-155200 $D=37
M88 92 4 GNDA GNDA nmos4 L=2e-05 W=2e-06 AD=1.7e-12 AS=1.7e-12 PD=3.7e-06 PS=3.7e-06 NRD=0.2125 NRS=0.2125 $X=167250 $Y=-232600 $D=37
M89 93 4 92 GNDA nmos4 L=2e-05 W=2e-06 AD=1.7e-12 AS=1.7e-12 PD=3.7e-06 PS=3.7e-06 NRD=0.2125 NRS=0.2125 $X=167250 $Y=-206800 $D=37
M90 94 4 93 GNDA nmos4 L=2e-05 W=2e-06 AD=1.7e-12 AS=1.7e-12 PD=3.7e-06 PS=3.7e-06 NRD=0.2125 NRS=0.2125 $X=167250 $Y=-181000 $D=37
M91 1 4 94 GNDA nmos4 L=2e-05 W=2e-06 AD=1.7e-12 AS=1.7e-12 PD=3.7e-06 PS=3.7e-06 NRD=0.2125 NRS=0.2125 $X=167250 $Y=-155200 $D=37
M92 95 4 GNDA GNDA nmos4 L=2e-05 W=2e-06 AD=1.7e-12 AS=1.7e-12 PD=3.7e-06 PS=3.7e-06 NRD=0.2125 NRS=0.2125 $X=170500 $Y=-232600 $D=37
M93 96 4 95 GNDA nmos4 L=2e-05 W=2e-06 AD=1.7e-12 AS=1.7e-12 PD=3.7e-06 PS=3.7e-06 NRD=0.2125 NRS=0.2125 $X=170500 $Y=-206800 $D=37
M94 97 4 96 GNDA nmos4 L=2e-05 W=2e-06 AD=1.7e-12 AS=1.7e-12 PD=3.7e-06 PS=3.7e-06 NRD=0.2125 NRS=0.2125 $X=170500 $Y=-181000 $D=37
M95 1 4 97 GNDA nmos4 L=2e-05 W=2e-06 AD=1.7e-12 AS=1.7e-12 PD=3.7e-06 PS=3.7e-06 NRD=0.2125 NRS=0.2125 $X=170500 $Y=-155200 $D=37
M96 98 4 GNDA GNDA nmos4 L=2e-05 W=2e-06 AD=1.7e-12 AS=1.7e-12 PD=3.7e-06 PS=3.7e-06 NRD=0.2125 NRS=0.2125 $X=173750 $Y=-232600 $D=37
M97 99 4 98 GNDA nmos4 L=2e-05 W=2e-06 AD=1.7e-12 AS=1.7e-12 PD=3.7e-06 PS=3.7e-06 NRD=0.2125 NRS=0.2125 $X=173750 $Y=-206800 $D=37
M98 100 4 99 GNDA nmos4 L=2e-05 W=2e-06 AD=1.7e-12 AS=1.7e-12 PD=3.7e-06 PS=3.7e-06 NRD=0.2125 NRS=0.2125 $X=173750 $Y=-181000 $D=37
M99 1 4 100 GNDA nmos4 L=2e-05 W=2e-06 AD=1.7e-12 AS=1.7e-12 PD=3.7e-06 PS=3.7e-06 NRD=0.2125 NRS=0.2125 $X=173750 $Y=-155200 $D=37
M100 101 4 GNDA GNDA nmos4 L=2e-05 W=2e-06 AD=1.7e-12 AS=1.7e-12 PD=3.7e-06 PS=3.7e-06 NRD=0.2125 NRS=0.2125 $X=177000 $Y=-232600 $D=37
M101 102 4 101 GNDA nmos4 L=2e-05 W=2e-06 AD=1.7e-12 AS=1.7e-12 PD=3.7e-06 PS=3.7e-06 NRD=0.2125 NRS=0.2125 $X=177000 $Y=-206800 $D=37
M102 103 4 102 GNDA nmos4 L=2e-05 W=2e-06 AD=1.7e-12 AS=1.7e-12 PD=3.7e-06 PS=3.7e-06 NRD=0.2125 NRS=0.2125 $X=177000 $Y=-181000 $D=37
M103 1 4 103 GNDA nmos4 L=2e-05 W=2e-06 AD=1.7e-12 AS=1.7e-12 PD=3.7e-06 PS=3.7e-06 NRD=0.2125 NRS=0.2125 $X=177000 $Y=-155200 $D=37
M104 104 5 GNDA GNDA nmos4 L=2e-05 W=2e-06 AD=1.7e-12 AS=1.7e-12 PD=3.7e-06 PS=3.7e-06 NRD=0.2125 NRS=0.2125 $X=204025 $Y=-232600 $D=37
M105 105 5 104 GNDA nmos4 L=2e-05 W=2e-06 AD=1.7e-12 AS=1.7e-12 PD=3.7e-06 PS=3.7e-06 NRD=0.2125 NRS=0.2125 $X=204025 $Y=-206800 $D=37
M106 106 5 105 GNDA nmos4 L=2e-05 W=2e-06 AD=1.7e-12 AS=1.7e-12 PD=3.7e-06 PS=3.7e-06 NRD=0.2125 NRS=0.2125 $X=204025 $Y=-181000 $D=37
M107 2 5 106 GNDA nmos4 L=2e-05 W=2e-06 AD=1.7e-12 AS=1.7e-12 PD=3.7e-06 PS=3.7e-06 NRD=0.2125 NRS=0.2125 $X=204025 $Y=-155200 $D=37
M108 107 5 GNDA GNDA nmos4 L=2e-05 W=2e-06 AD=1.7e-12 AS=1.7e-12 PD=3.7e-06 PS=3.7e-06 NRD=0.2125 NRS=0.2125 $X=207275 $Y=-232600 $D=37
M109 108 5 107 GNDA nmos4 L=2e-05 W=2e-06 AD=1.7e-12 AS=1.7e-12 PD=3.7e-06 PS=3.7e-06 NRD=0.2125 NRS=0.2125 $X=207275 $Y=-206800 $D=37
M110 109 5 108 GNDA nmos4 L=2e-05 W=2e-06 AD=1.7e-12 AS=1.7e-12 PD=3.7e-06 PS=3.7e-06 NRD=0.2125 NRS=0.2125 $X=207275 $Y=-181000 $D=37
M111 2 5 109 GNDA nmos4 L=2e-05 W=2e-06 AD=1.7e-12 AS=1.7e-12 PD=3.7e-06 PS=3.7e-06 NRD=0.2125 NRS=0.2125 $X=207275 $Y=-155200 $D=37
M112 110 5 GNDA GNDA nmos4 L=2e-05 W=2e-06 AD=1.7e-12 AS=1.7e-12 PD=3.7e-06 PS=3.7e-06 NRD=0.2125 NRS=0.2125 $X=210525 $Y=-232600 $D=37
M113 111 5 110 GNDA nmos4 L=2e-05 W=2e-06 AD=1.7e-12 AS=1.7e-12 PD=3.7e-06 PS=3.7e-06 NRD=0.2125 NRS=0.2125 $X=210525 $Y=-206800 $D=37
M114 112 5 111 GNDA nmos4 L=2e-05 W=2e-06 AD=1.7e-12 AS=1.7e-12 PD=3.7e-06 PS=3.7e-06 NRD=0.2125 NRS=0.2125 $X=210525 $Y=-181000 $D=37
M115 2 5 112 GNDA nmos4 L=2e-05 W=2e-06 AD=1.7e-12 AS=1.7e-12 PD=3.7e-06 PS=3.7e-06 NRD=0.2125 NRS=0.2125 $X=210525 $Y=-155200 $D=37
M116 113 5 GNDA GNDA nmos4 L=2e-05 W=2e-06 AD=1.7e-12 AS=1.7e-12 PD=3.7e-06 PS=3.7e-06 NRD=0.2125 NRS=0.2125 $X=213775 $Y=-232600 $D=37
M117 114 5 113 GNDA nmos4 L=2e-05 W=2e-06 AD=1.7e-12 AS=1.7e-12 PD=3.7e-06 PS=3.7e-06 NRD=0.2125 NRS=0.2125 $X=213775 $Y=-206800 $D=37
M118 115 5 114 GNDA nmos4 L=2e-05 W=2e-06 AD=1.7e-12 AS=1.7e-12 PD=3.7e-06 PS=3.7e-06 NRD=0.2125 NRS=0.2125 $X=213775 $Y=-181000 $D=37
M119 2 5 115 GNDA nmos4 L=2e-05 W=2e-06 AD=1.7e-12 AS=1.7e-12 PD=3.7e-06 PS=3.7e-06 NRD=0.2125 NRS=0.2125 $X=213775 $Y=-155200 $D=37
M120 116 5 GNDA GNDA nmos4 L=2e-05 W=2e-06 AD=1.7e-12 AS=1.7e-12 PD=3.7e-06 PS=3.7e-06 NRD=0.2125 NRS=0.2125 $X=217025 $Y=-232600 $D=37
M121 117 5 116 GNDA nmos4 L=2e-05 W=2e-06 AD=1.7e-12 AS=1.7e-12 PD=3.7e-06 PS=3.7e-06 NRD=0.2125 NRS=0.2125 $X=217025 $Y=-206800 $D=37
M122 118 5 117 GNDA nmos4 L=2e-05 W=2e-06 AD=1.7e-12 AS=1.7e-12 PD=3.7e-06 PS=3.7e-06 NRD=0.2125 NRS=0.2125 $X=217025 $Y=-181000 $D=37
M123 2 5 118 GNDA nmos4 L=2e-05 W=2e-06 AD=1.7e-12 AS=1.7e-12 PD=3.7e-06 PS=3.7e-06 NRD=0.2125 NRS=0.2125 $X=217025 $Y=-155200 $D=37
M124 119 5 GNDA GNDA nmos4 L=2e-05 W=2e-06 AD=1.7e-12 AS=1.7e-12 PD=3.7e-06 PS=3.7e-06 NRD=0.2125 NRS=0.2125 $X=220275 $Y=-232600 $D=37
M125 120 5 119 GNDA nmos4 L=2e-05 W=2e-06 AD=1.7e-12 AS=1.7e-12 PD=3.7e-06 PS=3.7e-06 NRD=0.2125 NRS=0.2125 $X=220275 $Y=-206800 $D=37
M126 121 5 120 GNDA nmos4 L=2e-05 W=2e-06 AD=1.7e-12 AS=1.7e-12 PD=3.7e-06 PS=3.7e-06 NRD=0.2125 NRS=0.2125 $X=220275 $Y=-181000 $D=37
M127 2 5 121 GNDA nmos4 L=2e-05 W=2e-06 AD=1.7e-12 AS=1.7e-12 PD=3.7e-06 PS=3.7e-06 NRD=0.2125 NRS=0.2125 $X=220275 $Y=-155200 $D=37
M128 153 5 GNDA GNDA nmos4 L=2e-05 W=2e-06 AD=1.7e-12 AS=1.7e-12 PD=3.7e-06 PS=3.7e-06 NRD=0.2125 NRS=0.2125 $X=249525 $Y=-232600 $D=37
M129 154 5 153 GNDA nmos4 L=2e-05 W=2e-06 AD=1.7e-12 AS=1.7e-12 PD=3.7e-06 PS=3.7e-06 NRD=0.2125 NRS=0.2125 $X=249525 $Y=-206800 $D=37
M130 155 5 154 GNDA nmos4 L=2e-05 W=2e-06 AD=1.7e-12 AS=1.7e-12 PD=3.7e-06 PS=3.7e-06 NRD=0.2125 NRS=0.2125 $X=249525 $Y=-181000 $D=37
M131 2 5 155 GNDA nmos4 L=2e-05 W=2e-06 AD=1.7e-12 AS=1.7e-12 PD=3.7e-06 PS=3.7e-06 NRD=0.2125 NRS=0.2125 $X=249525 $Y=-155200 $D=37
M132 156 5 GNDA GNDA nmos4 L=2e-05 W=2e-06 AD=1.7e-12 AS=1.7e-12 PD=3.7e-06 PS=3.7e-06 NRD=0.2125 NRS=0.2125 $X=252775 $Y=-232600 $D=37
M133 157 5 156 GNDA nmos4 L=2e-05 W=2e-06 AD=1.7e-12 AS=1.7e-12 PD=3.7e-06 PS=3.7e-06 NRD=0.2125 NRS=0.2125 $X=252775 $Y=-206800 $D=37
M134 158 5 157 GNDA nmos4 L=2e-05 W=2e-06 AD=1.7e-12 AS=1.7e-12 PD=3.7e-06 PS=3.7e-06 NRD=0.2125 NRS=0.2125 $X=252775 $Y=-181000 $D=37
M135 2 5 158 GNDA nmos4 L=2e-05 W=2e-06 AD=1.7e-12 AS=1.7e-12 PD=3.7e-06 PS=3.7e-06 NRD=0.2125 NRS=0.2125 $X=252775 $Y=-155200 $D=37
M136 159 5 GNDA GNDA nmos4 L=2e-05 W=2e-06 AD=1.7e-12 AS=1.7e-12 PD=3.7e-06 PS=3.7e-06 NRD=0.2125 NRS=0.2125 $X=256025 $Y=-232600 $D=37
M137 160 5 159 GNDA nmos4 L=2e-05 W=2e-06 AD=1.7e-12 AS=1.7e-12 PD=3.7e-06 PS=3.7e-06 NRD=0.2125 NRS=0.2125 $X=256025 $Y=-206800 $D=37
M138 161 5 160 GNDA nmos4 L=2e-05 W=2e-06 AD=1.7e-12 AS=1.7e-12 PD=3.7e-06 PS=3.7e-06 NRD=0.2125 NRS=0.2125 $X=256025 $Y=-181000 $D=37
M139 2 5 161 GNDA nmos4 L=2e-05 W=2e-06 AD=1.7e-12 AS=1.7e-12 PD=3.7e-06 PS=3.7e-06 NRD=0.2125 NRS=0.2125 $X=256025 $Y=-155200 $D=37
M140 162 5 GNDA GNDA nmos4 L=2e-05 W=2e-06 AD=1.7e-12 AS=1.7e-12 PD=3.7e-06 PS=3.7e-06 NRD=0.2125 NRS=0.2125 $X=259275 $Y=-232600 $D=37
M141 163 5 162 GNDA nmos4 L=2e-05 W=2e-06 AD=1.7e-12 AS=1.7e-12 PD=3.7e-06 PS=3.7e-06 NRD=0.2125 NRS=0.2125 $X=259275 $Y=-206800 $D=37
M142 164 5 163 GNDA nmos4 L=2e-05 W=2e-06 AD=1.7e-12 AS=1.7e-12 PD=3.7e-06 PS=3.7e-06 NRD=0.2125 NRS=0.2125 $X=259275 $Y=-181000 $D=37
M143 2 5 164 GNDA nmos4 L=2e-05 W=2e-06 AD=1.7e-12 AS=1.7e-12 PD=3.7e-06 PS=3.7e-06 NRD=0.2125 NRS=0.2125 $X=259275 $Y=-155200 $D=37
M144 165 5 GNDA GNDA nmos4 L=2e-05 W=2e-06 AD=1.7e-12 AS=1.7e-12 PD=3.7e-06 PS=3.7e-06 NRD=0.2125 NRS=0.2125 $X=262525 $Y=-232600 $D=37
M145 166 5 165 GNDA nmos4 L=2e-05 W=2e-06 AD=1.7e-12 AS=1.7e-12 PD=3.7e-06 PS=3.7e-06 NRD=0.2125 NRS=0.2125 $X=262525 $Y=-206800 $D=37
M146 167 5 166 GNDA nmos4 L=2e-05 W=2e-06 AD=1.7e-12 AS=1.7e-12 PD=3.7e-06 PS=3.7e-06 NRD=0.2125 NRS=0.2125 $X=262525 $Y=-181000 $D=37
M147 2 5 167 GNDA nmos4 L=2e-05 W=2e-06 AD=1.7e-12 AS=1.7e-12 PD=3.7e-06 PS=3.7e-06 NRD=0.2125 NRS=0.2125 $X=262525 $Y=-155200 $D=37
M148 168 5 GNDA GNDA nmos4 L=2e-05 W=2e-06 AD=1.7e-12 AS=1.7e-12 PD=3.7e-06 PS=3.7e-06 NRD=0.2125 NRS=0.2125 $X=265775 $Y=-232600 $D=37
M149 169 5 168 GNDA nmos4 L=2e-05 W=2e-06 AD=1.7e-12 AS=1.7e-12 PD=3.7e-06 PS=3.7e-06 NRD=0.2125 NRS=0.2125 $X=265775 $Y=-206800 $D=37
M150 170 5 169 GNDA nmos4 L=2e-05 W=2e-06 AD=1.7e-12 AS=1.7e-12 PD=3.7e-06 PS=3.7e-06 NRD=0.2125 NRS=0.2125 $X=265775 $Y=-181000 $D=37
M151 2 5 170 GNDA nmos4 L=2e-05 W=2e-06 AD=1.7e-12 AS=1.7e-12 PD=3.7e-06 PS=3.7e-06 NRD=0.2125 NRS=0.2125 $X=265775 $Y=-155200 $D=37
M152 VDDA VDDA VDDA VDDA pmos4 L=5e-06 W=6e-06 AD=5.1e-12 AS=5.1e-12 PD=7.7e-06 PS=7.7e-06 NRD=0.0708333 NRS=0.0708333 $X=50075 $Y=-83200 $D=42
M153 VDDA VDDA VDDA VDDA pmos4 L=5e-06 W=6e-06 AD=5.1e-12 AS=5.1e-12 PD=7.7e-06 PS=7.7e-06 NRD=0.0708333 NRS=0.0708333 $X=50075 $Y=-70800 $D=42
M154 VDDA VDDA VDDA VDDA pmos4 L=5e-06 W=6e-06 AD=5.1e-12 AS=5.1e-12 PD=7.7e-06 PS=7.7e-06 NRD=0.0708333 NRS=0.0708333 $X=137675 $Y=-83200 $D=42
M155 VDDA VDDA VDDA VDDA pmos4 L=5e-06 W=6e-06 AD=5.1e-12 AS=5.1e-12 PD=7.7e-06 PS=7.7e-06 NRD=0.0708333 NRS=0.0708333 $X=137675 $Y=-70800 $D=42
M156 2 18 VDDA VDDA pmos4 L=5e-06 W=6e-06 AD=5.1e-12 AS=5.1e-12 PD=7.7e-06 PS=7.7e-06 NRD=0.0708333 NRS=0.0708333 $X=79275 $Y=-83200 $D=41
M157 1 18 VDDA VDDA pmos4 L=5e-06 W=6e-06 AD=5.1e-12 AS=5.1e-12 PD=7.7e-06 PS=7.7e-06 NRD=0.0708333 NRS=0.0708333 $X=79275 $Y=-70800 $D=41
M158 1 18 VDDA VDDA pmos4 L=5e-06 W=6e-06 AD=5.1e-12 AS=5.1e-12 PD=7.7e-06 PS=7.7e-06 NRD=0.0708333 NRS=0.0708333 $X=108475 $Y=-83200 $D=41
M159 2 18 VDDA VDDA pmos4 L=5e-06 W=6e-06 AD=5.1e-12 AS=5.1e-12 PD=7.7e-06 PS=7.7e-06 NRD=0.0708333 NRS=0.0708333 $X=108475 $Y=-70800 $D=41
M160 OUT 7 23 VDDA pmos4 L=5e-06 W=5e-06 AD=4.25e-12 AS=4.25e-12 PD=6.7e-06 PS=6.7e-06 NRD=0.085 NRS=0.085 $X=291675 $Y=-69800 $D=41
M161 7 7 22 VDDA pmos4 L=5e-06 W=5e-06 AD=4.25e-12 AS=4.25e-12 PD=6.7e-06 PS=6.7e-06 NRD=0.085 NRS=0.085 $X=298975 $Y=-69800 $D=41
M162 22 7 VDDA VDDA pmos4 L=5e-06 W=5e-06 AD=4.25e-12 AS=4.25e-12 PD=6.7e-06 PS=6.7e-06 NRD=0.085 NRS=0.085 $X=306275 $Y=-69800 $D=41
M163 23 7 VDDA VDDA pmos4 L=5e-06 W=5e-06 AD=4.25e-12 AS=4.25e-12 PD=6.7e-06 PS=6.7e-06 NRD=0.085 NRS=0.085 $X=313575 $Y=-69800 $D=41
C164 GNDA BIAS $[cpolya] $A=900 $P=120 $X=62650 $Y=-270100 $D=58
C165 GNDA VDDA $[cpolya] $A=1494 $P=169.8 $X=388100 $Y=-55550 $D=58
X172 GNDA 10 cpolyc_CDNS_7807356271715 $T=950600 -261750 0 0 $X=949250 $Y=-263100
X173 GNDA 10 cpolyc_CDNS_7807356271715 $T=950600 -206050 0 0 $X=949250 $Y=-207400
X174 GNDA 10 cpolyc_CDNS_7807356271715 $T=950600 -150350 0 0 $X=949250 $Y=-151700
X175 GNDA 10 cpolyc_CDNS_7807356271715 $T=950600 -94650 0 0 $X=949250 $Y=-96000
X176 GNDA 10 ICV_15 $T=797600 -261750 0 0 $X=796250 $Y=-263100
X177 GNDA 10 ICV_15 $T=797600 -206050 0 0 $X=796250 $Y=-207400
X178 GNDA 10 ICV_15 $T=797600 -150350 0 0 $X=796250 $Y=-151700
X179 GNDA 10 ICV_15 $T=797600 -94650 0 0 $X=796250 $Y=-96000
X180 GNDA 12 cpolyc_CDNS_7807356271717 $T=577950 -39250 0 270 $X=576600 $Y=-109200
X181 GNDA 12 cpolyc_CDNS_7807356271717 $T=649050 -39250 0 270 $X=647700 $Y=-109200
X182 GNDA 12 cpolyc_CDNS_7807356271717 $T=720200 -39250 0 270 $X=718850 $Y=-109200
X183 GNDA 11 cpolyc_CDNS_7807356271718 $T=577950 -261750 0 0 $X=576600 $Y=-263100
X184 GNDA 11 cpolyc_CDNS_7807356271718 $T=577950 -197550 0 0 $X=576600 $Y=-198900
X185 GNDA 11 cpolyc_CDNS_7807356271718 $T=643700 -261750 0 0 $X=642350 $Y=-263100
X186 GNDA 11 cpolyc_CDNS_7807356271718 $T=643700 -197550 0 0 $X=642350 $Y=-198900
X187 GNDA 11 cpolyc_CDNS_7807356271718 $T=709450 -261750 0 0 $X=708100 $Y=-263100
X188 GNDA 11 cpolyc_CDNS_7807356271718 $T=709450 -197550 0 0 $X=708100 $Y=-198900
X189 GNDA OUT cpolyc_CDNS_7807356271723 $T=346000 -261750 0 0 $X=344650 $Y=-263100
X190 GNDA OUT cpolyc_CDNS_7807356271723 $T=460600 -148450 0 0 $X=459250 $Y=-149800
X191 GNDA OUT cpolyc_CDNS_7807356271723 $T=460650 -261750 0 0 $X=459300 $Y=-263100
X192 10 OUT S<2> GNDA nmos4_CDNS_7807356271711 $T=359700 -66150 0 90 $X=356750 $Y=-66550
X193 11 OUT S<1> GNDA nmos4_CDNS_7807356271711 $T=369950 -66150 0 90 $X=367000 $Y=-66550
X194 12 OUT S<0> GNDA nmos4_CDNS_7807356271711 $T=379650 -66150 0 90 $X=376700 $Y=-66550
X195 OUT 10 171 VDDA pmos4_CDNS_7807356271712 $T=357000 -57650 1 90 $X=355800 $Y=-58850
X196 OUT 11 24 VDDA pmos4_CDNS_7807356271712 $T=367250 -57650 1 90 $X=366050 $Y=-58850
X197 OUT 12 19 VDDA pmos4_CDNS_7807356271712 $T=376950 -57650 1 90 $X=375750 $Y=-58850
X198 S<0> VDDA GNDA 19 INVX1 $T=334400 -65900 0 0 $X=333550 $Y=-67250
X199 S<1> VDDA GNDA 24 INVX1 $T=339900 -65900 0 0 $X=339050 $Y=-67250
X200 S<2> VDDA GNDA 171 INVX1 $T=345550 -65900 0 0 $X=344700 $Y=-67250
X231 1 4 INN pmos4_CDNS_7807356271721 $T=194925 -101100 1 90 $X=193725 $Y=-102300
X232 2 5 INP pmos4_CDNS_7807356271721 $T=194925 -62000 0 270 $X=193725 $Y=-78200
X233 2 5 INP pmos4_CDNS_7807356271721 $T=234025 -101100 1 90 $X=232825 $Y=-102300
X234 1 4 INN pmos4_CDNS_7807356271721 $T=234025 -62000 0 270 $X=232825 $Y=-78200
X240 4 GNDA 58 58 62 62 66 66 70 70 74 74 78 78 82 82 7 GNDA ICV_19 $T=112000 -260050 0 0 $X=111600 $Y=-260300
X241 4 GNDA 55 GNDA 59 GNDA 63 GNDA 67 GNDA 71 GNDA 75 GNDA 79 GNDA 83 GNDA ICV_19 $T=112000 -233450 0 0 $X=111600 $Y=-233700
X242 4 55 56 59 60 63 64 67 68 71 72 75 76 79 80 83 84 GNDA ICV_19 $T=112000 -207650 0 0 $X=111600 $Y=-207900
X243 4 56 57 60 61 64 65 68 69 72 73 76 77 80 81 84 85 GNDA ICV_19 $T=112000 -181850 0 0 $X=111600 $Y=-182100
X244 4 57 1 61 1 65 1 69 1 73 1 77 1 81 1 85 1 GNDA ICV_19 $T=112000 -156050 0 0 $X=111600 $Y=-156300
X245 5 GNDA 125 125 129 129 133 133 137 137 141 141 145 145 149 149 OUT GNDA ICV_19 $T=200775 -259250 0 0 $X=200375 $Y=-259500
X246 5 GNDA 122 GNDA 126 GNDA 130 GNDA 134 GNDA 138 GNDA 142 GNDA 146 GNDA 150 GNDA ICV_19 $T=200775 -233450 0 0 $X=200375 $Y=-233700
X247 5 122 123 126 127 130 131 134 135 138 139 142 143 146 147 150 151 GNDA ICV_19 $T=200775 -207650 0 0 $X=200375 $Y=-207900
X248 5 123 124 127 128 131 132 135 136 139 140 143 144 147 148 151 152 GNDA ICV_19 $T=200775 -181850 0 0 $X=200375 $Y=-182100
X249 5 124 2 128 2 132 2 136 2 140 2 144 2 148 2 152 2 GNDA ICV_19 $T=200775 -156050 0 0 $X=200375 $Y=-156300
X259 VDDA 1 2 1 18 ICV_21 $T=49225 -77200 0 270 $X=48025 $Y=-84400
X260 VDDA 2 1 2 18 ICV_21 $T=49225 -64800 0 270 $X=48025 $Y=-72000
X261 VDDA 1 18 2 18 ICV_21 $T=78425 -77200 0 270 $X=77225 $Y=-84400
X262 VDDA 2 18 1 18 ICV_21 $T=78425 -64800 0 270 $X=77225 $Y=-72000
X263 VDDA 2 1 2 18 ICV_21 $T=107625 -77200 0 270 $X=106425 $Y=-84400
X264 VDDA 1 2 1 18 ICV_21 $T=107625 -64800 0 270 $X=106425 $Y=-72000
X273 GNDA ICV_22 $T=75375 -223600 0 0 $X=74975 $Y=-223850
X274 GNDA ICV_22 $T=75375 -150600 0 0 $X=74975 $Y=-150850
X279 GNDA ICV_24 $T=36375 -223600 0 0 $X=35975 $Y=-223850
X280 GNDA ICV_24 $T=36375 -150600 0 0 $X=35975 $Y=-150850
X281 GNDA ICV_24 $T=49375 -223600 0 0 $X=48975 $Y=-223850
X282 GNDA ICV_24 $T=49375 -150600 0 0 $X=48975 $Y=-150850
X283 GNDA ICV_24 $T=62375 -223600 0 0 $X=61975 $Y=-223850
X284 GNDA ICV_24 $T=62375 -150600 0 0 $X=61975 $Y=-150850
X289 21 18 BIAS GNDA nmos4_CDNS_7807356271714 $T=44425 -116900 0 270 $X=44175 $Y=-127450
X290 20 BIAS BIAS GNDA nmos4_CDNS_7807356271714 $T=56225 -116900 0 270 $X=55975 $Y=-127450
X291 20 26 5 26 5 30 26 30 26 34 30 GNDA ICV_26 $T=36375 -213800 0 0 $X=35975 $Y=-214050
X292 20 27 4 27 4 31 27 31 27 35 31 GNDA ICV_26 $T=36375 -198000 0 0 $X=35975 $Y=-198250
X293 20 GNDA 25 25 29 25 29 29 32 32 20 GNDA ICV_26 $T=36375 -182200 0 0 $X=35975 $Y=-182450
X294 20 28 21 28 21 33 28 33 28 36 33 GNDA ICV_26 $T=36375 -166400 0 0 $X=35975 $Y=-166650
.ENDS
***************************************
.SUBCKT rpolyhc_CDNS_7807356271768 1 2 3
** N=3 EP=3 IP=0 FDC=2
R0 1 2 L=0.00499975 W=8e-07 $[rpolyh] $X=-800 $Y=1550 $D=18
D1 3 3 p_nwd AREA=10336.4 PJ=480.7 $X=-6650 $Y=-5950 $D=87
.ENDS
***************************************
.SUBCKT ND_C_CDNS_78073562717241
** N=2 EP=0 IP=0 FDC=0
.ENDS
***************************************
.SUBCKT nmos4_CDNS_7807356271760
** N=4 EP=0 IP=0 FDC=0
.ENDS
***************************************
.SUBCKT nmos4_CDNS_7807356271755
** N=3 EP=0 IP=0 FDC=0
.ENDS
***************************************
.SUBCKT pmos4_CDNS_7807356271754
** N=4 EP=0 IP=0 FDC=0
.ENDS
***************************************
.SUBCKT ICV_27 1 3 5
** N=5 EP=3 IP=6 FDC=1
M0 3 5 1 1 nmos4 L=1e-06 W=5e-06 AD=4.25e-12 AS=4.25e-12 PD=6.7e-06 PS=6.7e-06 NRD=0.085 NRS=0.085 $X=0 $Y=4150 $D=37
.ENDS
***************************************
.SUBCKT ICV_28 1 3 4 6
** N=6 EP=4 IP=10 FDC=3
M0 4 6 1 1 nmos4 L=1e-06 W=5e-06 AD=4.25e-12 AS=4.25e-12 PD=6.7e-06 PS=6.7e-06 NRD=0.085 NRS=0.085 $X=0 $Y=7450 $D=37
X1 1 3 6 ICV_27 $T=0 0 0 0 $X=-400 $Y=-250
X2 1 3 6 ICV_27 $T=0 6600 0 0 $X=-400 $Y=6350
.ENDS
***************************************
.SUBCKT ICV_29 1 2 3 4
** N=5 EP=4 IP=8 FDC=2
M0 2 4 1 1 pmos4 L=3e-06 W=1e-05 AD=8.5e-12 AS=8.5e-12 PD=1.17e-05 PS=1.17e-05 NRD=0.0425 NRS=0.0425 $X=0 $Y=850 $D=41
M1 3 4 1 1 pmos4 L=3e-06 W=1e-05 AD=8.5e-12 AS=8.5e-12 PD=1.17e-05 PS=1.17e-05 NRD=0.0425 NRS=0.0425 $X=0 $Y=6150 $D=41
.ENDS
***************************************
.SUBCKT ICV_30 1 2 3 4
*.CALIBRE ICV_CELL 9
** N=5 EP=4 IP=10 FDC=4
X0 1 2 3 4 ICV_29 $T=0 0 0 0 $X=-1200 $Y=-1200
X1 1 2 2 4 ICV_29 $T=0 10600 0 0 $X=-1200 $Y=9400
.ENDS
***************************************
.SUBCKT ICV_31 1 2 3
** N=3 EP=3 IP=12 FDC=8
M0 1 1 1 1 nmos4 L=1e-06 W=5e-06 AD=4.25e-12 AS=4.25e-12 PD=6.7e-06 PS=6.7e-06 NRD=0.085 NRS=0.085 $X=0 $Y=850 $D=38
M1 2 3 1 1 nmos4 L=1e-06 W=5e-06 AD=4.25e-12 AS=4.25e-12 PD=6.7e-06 PS=6.7e-06 NRD=0.085 NRS=0.085 $X=0 $Y=14050 $D=37
X2 1 2 2 3 ICV_28 $T=0 0 0 0 $X=-400 $Y=-250
X3 1 2 3 3 ICV_28 $T=0 13200 0 0 $X=-400 $Y=12950
.ENDS
***************************************
.SUBCKT pmos4_CDNS_7807356271756
** N=4 EP=0 IP=0 FDC=0
.ENDS
***************************************
.SUBCKT ICV_32
** N=6 EP=0 IP=8 FDC=0
.ENDS
***************************************
.SUBCKT P1_C_CDNS_78073562717268
** N=2 EP=0 IP=0 FDC=0
.ENDS
***************************************
.SUBCKT nmos4_CDNS_7807356271752 1 2 3
** N=3 EP=3 IP=0 FDC=1
M0 2 3 1 1 nmos4 L=4e-06 W=4e-06 AD=3.4e-12 AS=3.4e-12 PD=5.7e-06 PS=5.7e-06 NRD=0.10625 NRS=0.10625 $X=0 $Y=850 $D=37
.ENDS
***************************************
.SUBCKT ICV_33 1 2 3 5 6
** N=8 EP=5 IP=12 FDC=3
M0 2 5 1 1 pmos4 L=3.5e-07 W=5e-06 AD=4.25e-12 AS=4.25e-12 PD=6.7e-06 PS=6.7e-06 NRD=0.085 NRS=0.085 $X=0 $Y=-7100 $D=41
M1 2 5 1 1 pmos4 L=3.5e-07 W=5e-06 AD=4.25e-12 AS=4.25e-12 PD=6.7e-06 PS=6.7e-06 NRD=0.085 NRS=0.085 $X=0 $Y=-4450 $D=41
M2 3 6 1 1 pmos4 L=3.5e-07 W=5e-06 AD=4.25e-12 AS=4.25e-12 PD=6.7e-06 PS=6.7e-06 NRD=0.085 NRS=0.085 $X=0 $Y=-1800 $D=41
.ENDS
***************************************
.SUBCKT nmos4_CDNS_7807356271753 1 2 3 4
** N=4 EP=4 IP=0 FDC=2
M0 2 3 1 4 nmos4 L=1e-06 W=1e-05 AD=5e-12 AS=8.5e-12 PD=1e-06 PS=1.17e-05 NRD=0.0425 NRS=0.0425 $X=0 $Y=850 $D=37
M1 1 3 2 4 nmos4 L=1e-06 W=1e-05 AD=8.5e-12 AS=5e-12 PD=1.17e-05 PS=1e-06 NRD=0.0425 NRS=0.0425 $X=0 $Y=2850 $D=37
.ENDS
***************************************
.SUBCKT cmfb_opamp1_fc 1 2 OUT GNDA VDDA INP INN BIAS
** N=12 EP=8 IP=169 FDC=90
D0 GNDA 10 p_nwd AREA=2103.7 PJ=186.2 $X=7125 $Y=53475 $D=87
D1 GNDA VDDA p_nwd AREA=5361.48 PJ=295.8 $X=65050 $Y=64650 $D=87
M2 GNDA GNDA GNDA GNDA nmos4 L=1e-06 W=5e-06 AD=4.25e-12 AS=4.25e-12 PD=6.7e-06 PS=6.7e-06 NRD=0.085 NRS=0.085 $X=134675 $Y=32950 $D=38
M3 GNDA GNDA GNDA GNDA nmos4 L=1e-06 W=5e-06 AD=4.25e-12 AS=4.25e-12 PD=6.7e-06 PS=6.7e-06 NRD=0.085 NRS=0.085 $X=134675 $Y=41450 $D=38
M4 9 9 GNDA GNDA nmos4 L=1e-06 W=5e-06 AD=2.5e-12 AS=4.25e-12 PD=1e-06 PS=6.7e-06 NRD=0.085 NRS=0.085 $X=52300 $Y=29850 $D=37
M5 GNDA 9 9 GNDA nmos4 L=1e-06 W=5e-06 AD=4.25e-12 AS=2.5e-12 PD=6.7e-06 PS=1e-06 NRD=0.085 NRS=0.085 $X=54300 $Y=29850 $D=37
M6 OUT 1 GNDA GNDA nmos4 L=1e-06 W=5e-06 AD=4.25e-12 AS=4.25e-12 PD=6.7e-06 PS=6.7e-06 NRD=0.085 NRS=0.085 $X=121475 $Y=32950 $D=37
M7 OUT 1 GNDA GNDA nmos4 L=1e-06 W=5e-06 AD=4.25e-12 AS=4.25e-12 PD=6.7e-06 PS=6.7e-06 NRD=0.085 NRS=0.085 $X=121475 $Y=41450 $D=37
M8 10 10 10 10 pmos4 L=3.5e-07 W=5e-06 AD=4.25e-12 AS=4.25e-12 PD=6.7e-06 PS=6.7e-06 NRD=0.085 NRS=0.085 $X=22275 $Y=63775 $D=42
M9 10 10 10 10 pmos4 L=3.5e-07 W=5e-06 AD=4.25e-12 AS=4.25e-12 PD=6.7e-06 PS=6.7e-06 NRD=0.085 NRS=0.085 $X=22275 $Y=76775 $D=42
M10 10 10 10 10 pmos4 L=3.5e-07 W=5e-06 AD=4.25e-12 AS=4.25e-12 PD=6.7e-06 PS=6.7e-06 NRD=0.085 NRS=0.085 $X=46125 $Y=63775 $D=42
M11 10 10 10 10 pmos4 L=3.5e-07 W=5e-06 AD=4.25e-12 AS=4.25e-12 PD=6.7e-06 PS=6.7e-06 NRD=0.085 NRS=0.085 $X=46125 $Y=76775 $D=42
M12 VDDA VDDA VDDA VDDA pmos4 L=3e-06 W=1e-05 AD=8.5e-12 AS=8.5e-12 PD=1.17e-05 PS=1.17e-05 NRD=0.0425 NRS=0.0425 $X=132200 $Y=74950 $D=42
M13 VDDA VDDA VDDA VDDA pmos4 L=3e-06 W=1e-05 AD=8.5e-12 AS=8.5e-12 PD=1.17e-05 PS=1.17e-05 NRD=0.0425 NRS=0.0425 $X=132200 $Y=92950 $D=42
M14 10 INP 1 10 pmos4 L=3.5e-07 W=5e-06 AD=4.25e-12 AS=4.25e-12 PD=6.7e-06 PS=6.7e-06 NRD=0.085 NRS=0.085 $X=32875 $Y=63775 $D=41
M15 10 INN 9 10 pmos4 L=3.5e-07 W=5e-06 AD=4.25e-12 AS=4.25e-12 PD=6.7e-06 PS=6.7e-06 NRD=0.085 NRS=0.085 $X=32875 $Y=76775 $D=41
M16 10 INP 1 10 pmos4 L=3.5e-07 W=5e-06 AD=4.25e-12 AS=4.25e-12 PD=6.7e-06 PS=6.7e-06 NRD=0.085 NRS=0.085 $X=43475 $Y=63775 $D=41
M17 10 INN 9 10 pmos4 L=3.5e-07 W=5e-06 AD=4.25e-12 AS=4.25e-12 PD=6.7e-06 PS=6.7e-06 NRD=0.085 NRS=0.085 $X=43475 $Y=76775 $D=41
M18 OUT 2 VDDA VDDA pmos4 L=3e-06 W=1e-05 AD=8.5e-12 AS=8.5e-12 PD=1.17e-05 PS=1.17e-05 NRD=0.0425 NRS=0.0425 $X=132200 $Y=110950 $D=41
C19 2 VDDA $[cpolya] $A=1345.5 $P=149.7 $X=10650 $Y=95600 $D=58
X38 GNDA OUT OUT 1 ICV_28 $T=120625 37950 0 270 $X=120375 $Y=32550
X39 GNDA OUT OUT 1 ICV_28 $T=120625 46450 0 270 $X=120375 $Y=41050
X40 VDDA OUT OUT 2 ICV_29 $T=120750 84950 0 270 $X=119550 $Y=73750
X41 VDDA OUT OUT 2 ICV_29 $T=120750 102950 0 270 $X=119550 $Y=91750
X42 VDDA OUT OUT 2 ICV_29 $T=120750 120950 0 270 $X=119550 $Y=109750
X43 VDDA OUT OUT 2 ICV_30 $T=78350 84950 0 270 $X=77150 $Y=73750
X44 VDDA OUT OUT 2 ICV_30 $T=78350 102950 0 270 $X=77150 $Y=91750
X45 VDDA OUT OUT 2 ICV_30 $T=78350 120950 0 270 $X=77150 $Y=109750
X46 VDDA OUT 10 2 ICV_30 $T=99550 84950 0 270 $X=98350 $Y=73750
X47 VDDA 10 2 2 ICV_30 $T=99550 102950 0 270 $X=98350 $Y=91750
X48 VDDA OUT 10 2 ICV_30 $T=99550 120950 0 270 $X=98350 $Y=109750
X49 GNDA OUT 1 ICV_31 $T=94225 37950 0 270 $X=93975 $Y=32550
X50 GNDA OUT 1 ICV_31 $T=94225 46450 0 270 $X=93975 $Y=41050
X55 GNDA 11 11 nmos4_CDNS_7807356271752 $T=37400 29950 0 90 $X=31450 $Y=29550
X56 GNDA 12 11 nmos4_CDNS_7807356271752 $T=43700 29950 0 90 $X=37750 $Y=29550
X57 10 9 1 INN INP ICV_33 $T=23475 63775 0 90 $X=20225 $Y=62575
X58 10 1 9 INP INN ICV_33 $T=23475 76775 0 90 $X=20225 $Y=75575
X59 10 9 1 INN INP ICV_33 $T=34075 63775 0 90 $X=30825 $Y=62575
X60 10 1 9 INP INN ICV_33 $T=34075 76775 0 90 $X=30825 $Y=75575
X61 11 BIAS BIAS GNDA nmos4_CDNS_7807356271753 $T=18350 33400 0 90 $X=13400 $Y=32700
X62 12 2 BIAS GNDA nmos4_CDNS_7807356271753 $T=23650 33400 0 90 $X=18700 $Y=32700
.ENDS
***************************************
.SUBCKT rpolyhc_CDNS_7807356271759 1 2
** N=3 EP=2 IP=0 FDC=1
R0 1 2 L=0.00049995 W=8e-07 $[rpolyh] $X=-800 $Y=1550 $D=18
.ENDS
***************************************
.SUBCKT ICV_34
** N=7 EP=0 IP=8 FDC=0
.ENDS
***************************************
.SUBCKT ICV_35 1 2 3 6 7 9
** N=9 EP=6 IP=14 FDC=3
M0 2 6 1 9 nmos4 L=3.5e-07 W=5e-06 AD=4.25e-12 AS=4.25e-12 PD=6.7e-06 PS=6.7e-06 NRD=0.085 NRS=0.085 $X=0 $Y=-7100 $D=37
M1 2 7 3 9 nmos4 L=3.5e-07 W=5e-06 AD=4.25e-12 AS=4.25e-12 PD=6.7e-06 PS=6.7e-06 NRD=0.085 NRS=0.085 $X=0 $Y=-4450 $D=37
M2 2 6 1 9 nmos4 L=3.5e-07 W=5e-06 AD=4.25e-12 AS=4.25e-12 PD=6.7e-06 PS=6.7e-06 NRD=0.085 NRS=0.085 $X=0 $Y=-1800 $D=37
.ENDS
***************************************
.SUBCKT pmos4_CDNS_7807356271748 1 2 3 5
** N=5 EP=4 IP=0 FDC=2
M0 2 3 1 5 pmos4 L=1e-06 W=5e-06 AD=2.5e-12 AS=4.25e-12 PD=1e-06 PS=6.7e-06 NRD=0.085 NRS=0.085 $X=0 $Y=850 $D=41
M1 1 3 2 5 pmos4 L=1e-06 W=5e-06 AD=4.25e-12 AS=2.5e-12 PD=6.7e-06 PS=1e-06 NRD=0.085 NRS=0.085 $X=0 $Y=2850 $D=41
.ENDS
***************************************
.SUBCKT nmos4_CDNS_7807356271762
** N=3 EP=0 IP=0 FDC=0
.ENDS
***************************************
.SUBCKT PD_C_CDNS_78073562717219
** N=1 EP=0 IP=0 FDC=0
.ENDS
***************************************
.SUBCKT pmos4_CDNS_7807356271763
** N=4 EP=0 IP=0 FDC=0
.ENDS
***************************************
.SUBCKT ICV_36 1 2 4
** N=6 EP=3 IP=8 FDC=1
M0 2 4 1 1 pmos4 L=3e-06 W=5e-06 AD=4.25e-12 AS=4.25e-12 PD=6.7e-06 PS=6.7e-06 NRD=0.085 NRS=0.085 $X=0 $Y=-4450 $D=41
.ENDS
***************************************
.SUBCKT ICV_37 1 2 4
** N=5 EP=3 IP=6 FDC=1
M0 2 4 1 1 nmos4 L=1e-05 W=8e-06 AD=6.8e-12 AS=6.8e-12 PD=9.7e-06 PS=9.7e-06 NRD=0.053125 NRS=0.053125 $X=0 $Y=-11950 $D=37
.ENDS
***************************************
.SUBCKT ICV_38 1 2 3 4 6
** N=7 EP=5 IP=10 FDC=3
M0 3 6 1 1 nmos4 L=1e-05 W=8e-06 AD=6.8e-12 AS=6.8e-12 PD=9.7e-06 PS=9.7e-06 NRD=0.053125 NRS=0.053125 $X=0 $Y=-24750 $D=37
X1 1 2 6 ICV_37 $T=0 -25600 0 0 $X=-400 $Y=-38650
X2 1 4 6 ICV_37 $T=0 0 0 0 $X=-400 $Y=-13050
.ENDS
***************************************
.SUBCKT fecg_cmfb2_fc CM VREF_CM EN_CMFB BIAS VDDA GNDA INP INN CMFB 10
** N=27 EP=10 IP=230 FDC=267
R0 18 CMFB L=0.00499765 W=8e-07 $[rpolyh] $X=259225 $Y=145800 $D=18
D1 GNDA VDDA p_nwd AREA=2047.5 PJ=184.2 $X=57475 $Y=165200 $D=87
D2 GNDA VDDA p_nwd AREA=850.2 PJ=117.4 $X=118200 $Y=170000 $D=87
D3 GNDA GNDA p_nwd AREA=13200.1 PJ=568 $X=206625 $Y=139700 $D=87
D4 GNDA VDDA p_nwd AREA=52.15 PJ=28.9 $X=455350 $Y=158300 $D=87
D5 GNDA VDDA p_nwd AREA=52.15 PJ=28.9 $X=455350 $Y=177025 $D=87
D6 GNDA VDDA p_nwd AREA=22.25 PJ=18.9 $X=457375 $Y=138350 $D=87
M7 GNDA GNDA GNDA GNDA nmos4 L=1e-05 W=8e-06 AD=6.8e-12 AS=6.8e-12 PD=9.7e-06 PS=9.7e-06 NRD=0.053125 NRS=0.053125 $X=28625 $Y=30100 $D=38
M8 GNDA GNDA GNDA GNDA nmos4 L=1e-05 W=8e-06 AD=6.8e-12 AS=6.8e-12 PD=9.7e-06 PS=9.7e-06 NRD=0.053125 NRS=0.053125 $X=28625 $Y=40800 $D=38
M9 GNDA GNDA GNDA GNDA nmos4 L=1e-05 W=8e-06 AD=6.8e-12 AS=6.8e-12 PD=9.7e-06 PS=9.7e-06 NRD=0.053125 NRS=0.053125 $X=131025 $Y=30100 $D=38
M10 GNDA GNDA GNDA GNDA nmos4 L=1e-05 W=8e-06 AD=6.8e-12 AS=6.8e-12 PD=9.7e-06 PS=9.7e-06 NRD=0.053125 NRS=0.053125 $X=131025 $Y=40800 $D=38
M11 GNDA GNDA GNDA GNDA nmos4 L=3.5e-07 W=5e-06 AD=4.25e-12 AS=4.25e-12 PD=6.7e-06 PS=6.7e-06 NRD=0.085 NRS=0.085 $X=162975 $Y=175750 $D=38
M12 GNDA GNDA GNDA GNDA nmos4 L=3.5e-07 W=5e-06 AD=4.25e-12 AS=4.25e-12 PD=6.7e-06 PS=6.7e-06 NRD=0.085 NRS=0.085 $X=162975 $Y=188050 $D=38
M13 GNDA GNDA GNDA GNDA nmos4 L=3.5e-07 W=5e-06 AD=4.25e-12 AS=4.25e-12 PD=6.7e-06 PS=6.7e-06 NRD=0.085 NRS=0.085 $X=186825 $Y=175750 $D=38
M14 GNDA GNDA GNDA GNDA nmos4 L=3.5e-07 W=5e-06 AD=4.25e-12 AS=4.25e-12 PD=6.7e-06 PS=6.7e-06 NRD=0.085 NRS=0.085 $X=186825 $Y=188050 $D=38
M15 GNDA 14 13 GNDA nmos4 L=1e-05 W=8e-06 AD=6.8e-12 AS=6.8e-12 PD=9.7e-06 PS=9.7e-06 NRD=0.053125 NRS=0.053125 $X=79825 $Y=30100 $D=37
M16 GNDA 14 12 GNDA nmos4 L=1e-05 W=8e-06 AD=6.8e-12 AS=6.8e-12 PD=9.7e-06 PS=9.7e-06 NRD=0.053125 NRS=0.053125 $X=79825 $Y=40800 $D=37
M17 13 INP VDDA GNDA nmos4 L=3.5e-07 W=5e-06 AD=4.25e-12 AS=4.25e-12 PD=6.7e-06 PS=6.7e-06 NRD=0.085 NRS=0.085 $X=173575 $Y=175750 $D=37
M18 12 INN VDDA GNDA nmos4 L=3.5e-07 W=5e-06 AD=4.25e-12 AS=4.25e-12 PD=6.7e-06 PS=6.7e-06 NRD=0.085 NRS=0.085 $X=173575 $Y=188050 $D=37
M19 12 INN VDDA GNDA nmos4 L=3.5e-07 W=5e-06 AD=4.25e-12 AS=4.25e-12 PD=6.7e-06 PS=6.7e-06 NRD=0.085 NRS=0.085 $X=184175 $Y=175750 $D=37
M20 13 INP VDDA GNDA nmos4 L=3.5e-07 W=5e-06 AD=4.25e-12 AS=4.25e-12 PD=6.7e-06 PS=6.7e-06 NRD=0.085 NRS=0.085 $X=184175 $Y=188050 $D=37
M21 20 EN_CMFB INP GNDA nmos4 L=3.5e-07 W=5e-06 AD=4.25e-12 AS=4.25e-12 PD=6.7e-06 PS=6.7e-06 NRD=0.085 NRS=0.085 $X=456550 $Y=173325 $D=37
M22 21 EN_CMFB INN GNDA nmos4 L=3.5e-07 W=5e-06 AD=4.25e-12 AS=4.25e-12 PD=6.7e-06 PS=6.7e-06 NRD=0.085 NRS=0.085 $X=456600 $Y=154600 $D=37
M23 VDDA VDDA VDDA VDDA pmos4 L=3e-06 W=5e-06 AD=4.25e-12 AS=4.25e-12 PD=6.7e-06 PS=6.7e-06 NRD=0.085 NRS=0.085 $X=72675 $Y=176550 $D=42
M24 VDDA VDDA VDDA VDDA pmos4 L=3e-06 W=5e-06 AD=4.25e-12 AS=4.25e-12 PD=6.7e-06 PS=6.7e-06 NRD=0.085 NRS=0.085 $X=72675 $Y=186350 $D=42
M25 VDDA VDDA VDDA VDDA pmos4 L=3e-06 W=5e-06 AD=4.25e-12 AS=4.25e-12 PD=6.7e-06 PS=6.7e-06 NRD=0.085 NRS=0.085 $X=93875 $Y=176550 $D=42
M26 VDDA VDDA VDDA VDDA pmos4 L=3e-06 W=5e-06 AD=4.25e-12 AS=4.25e-12 PD=6.7e-06 PS=6.7e-06 NRD=0.085 NRS=0.085 $X=93875 $Y=186350 $D=42
M27 VDDA 22 16 VDDA pmos4 L=3e-06 W=5e-06 AD=4.25e-12 AS=4.25e-12 PD=6.7e-06 PS=6.7e-06 NRD=0.085 NRS=0.085 $X=83275 $Y=176550 $D=41
M28 VDDA 22 16 VDDA pmos4 L=3e-06 W=5e-06 AD=4.25e-12 AS=4.25e-12 PD=6.7e-06 PS=6.7e-06 NRD=0.085 NRS=0.085 $X=83275 $Y=186350 $D=41
M29 INN 27 21 VDDA pmos4 L=3.5e-07 W=5e-06 AD=2.5e-12 AS=4.25e-12 PD=1e-06 PS=6.7e-06 NRD=0.085 NRS=0.085 $X=456600 $Y=160350 $D=41
M30 21 27 INN VDDA pmos4 L=3.5e-07 W=5e-06 AD=4.25e-12 AS=2.5e-12 PD=6.7e-06 PS=1e-06 NRD=0.085 NRS=0.085 $X=456600 $Y=161700 $D=41
M31 INP 27 20 VDDA pmos4 L=3.5e-07 W=5e-06 AD=2.5e-12 AS=4.25e-12 PD=1e-06 PS=6.7e-06 NRD=0.085 NRS=0.085 $X=456600 $Y=179075 $D=41
M32 20 27 INP VDDA pmos4 L=3.5e-07 W=5e-06 AD=4.25e-12 AS=2.5e-12 PD=6.7e-06 PS=1e-06 NRD=0.085 NRS=0.085 $X=456600 $Y=180425 $D=41
C33 22 VDDA $[cpolya] $A=875 $P=120 $X=16850 $Y=168650 $D=58
C34 GNDA BIAS $[cpolya] $A=1495.5 $P=159.7 $X=19525 $Y=94275 $D=58
C35 GNDA VDDA $[cpolya] $A=6400 $P=320 $X=59150 $Y=70600 $D=58
C36 GNDA VDDA $[cpolya] $A=600 $P=100 $X=170350 $Y=141600 $D=58
X44 VDDA 27 EN_CMFB pmos4_CDNS_7807356271735 $T=458575 140950 0 270 $X=457375 $Y=138350
X45 GNDA 27 EN_CMFB nmos4_CDNS_7807356271734 $T=458575 137125 0 270 $X=458325 $Y=135925
X46 14 BIAS BIAS GNDA nmos4_CDNS_7807356271761 $T=21475 75425 0 90 $X=12525 $Y=75025
X47 11 23 BIAS GNDA nmos4_CDNS_7807356271761 $T=30775 75425 0 90 $X=21825 $Y=75025
X56 20 CMFB GNDA rpolyhc_CDNS_7807356271768 $T=519650 188900 1 270 $X=469500 $Y=11300
X57 CMFB 21 GNDA rpolyhc_CDNS_7807356271768 $T=533550 17950 1 90 $X=527600 $Y=11300
X62 17 25 CM GNDA VDDA 18 CM 24 cmfb_opamp1_fc $T=159600 -12050 0 0 $X=164725 $Y=5998
X63 19 26 CMFB GNDA VDDA VREF_CM 18 10 cmfb_opamp1_fc $T=313550 -12050 0 0 $X=318675 $Y=5998
X64 18 13 rpolyhc_CDNS_7807356271759 $T=229125 146600 0 90 $X=208175 $Y=141250
X65 12 18 rpolyhc_CDNS_7807356271759 $T=252325 190750 1 270 $X=231375 $Y=141250
X68 12 VDDA 13 INN INP GNDA ICV_35 $T=164175 175750 0 90 $X=161875 $Y=175350
X69 13 VDDA 12 INP INN GNDA ICV_35 $T=164175 188050 0 90 $X=161875 $Y=187650
X70 13 VDDA 12 INP INN GNDA ICV_35 $T=174775 175750 0 90 $X=172475 $Y=175350
X71 12 VDDA 13 INN INP GNDA ICV_35 $T=174775 188050 0 90 $X=172475 $Y=187650
X72 22 23 23 VDDA pmos4_CDNS_7807356271748 $T=128250 176350 0 90 $X=122350 $Y=175150
X73 16 24 23 VDDA pmos4_CDNS_7807356271748 $T=133550 176350 0 90 $X=127650 $Y=175150
X74 15 10 23 VDDA pmos4_CDNS_7807356271748 $T=138850 176350 0 90 $X=132950 $Y=175150
X93 VDDA 22 22 ICV_36 $T=76525 176550 0 90 $X=70625 $Y=175350
X94 VDDA 15 22 ICV_36 $T=76525 186350 0 90 $X=70625 $Y=185150
X95 VDDA 15 22 ICV_36 $T=87125 176550 0 90 $X=81225 $Y=175350
X96 VDDA 22 22 ICV_36 $T=87125 186350 0 90 $X=81225 $Y=185150
X97 GNDA 14 12 13 14 ICV_38 $T=39475 30100 0 90 $X=27525 $Y=29700
X98 GNDA 11 13 12 14 ICV_38 $T=39475 40800 0 90 $X=27525 $Y=40400
X99 GNDA 13 12 11 14 ICV_38 $T=90675 30100 0 90 $X=78725 $Y=29700
X100 GNDA 12 13 14 14 ICV_38 $T=90675 40800 0 90 $X=78725 $Y=40400
.ENDS
***************************************
.SUBCKT cpolyc_CDNS_7807356271736 2 3
** N=3 EP=2 IP=0 FDC=1
C0 2 3 $[cpolya] $A=2595.9 $P=203.8 $X=1800 $Y=1000 $D=58
.ENDS
***************************************
.SUBCKT rpolyhc_CDNS_7807356271747 1
** N=2 EP=1 IP=0 FDC=1
R0 1 1 L=4.99897e-06 W=8e-07 $[rpolyh] $X=600 $Y=0 $D=17
.ENDS
***************************************
.SUBCKT P1_C_CDNS_78073562717145
** N=2 EP=0 IP=0 FDC=0
.ENDS
***************************************
.SUBCKT pmos4_CDNS_7807356271741
** N=4 EP=0 IP=0 FDC=0
.ENDS
***************************************
.SUBCKT ICV_39
** N=6 EP=0 IP=8 FDC=0
.ENDS
***************************************
.SUBCKT ICV_40
** N=8 EP=0 IP=12 FDC=0
.ENDS
***************************************
.SUBCKT ICV_41 1
** N=9 EP=1 IP=16 FDC=1
M0 1 1 1 1 pmos4 L=1.2e-05 W=1e-05 AD=8.5e-12 AS=8.5e-12 PD=1.17e-05 PS=1.17e-05 NRD=0.0425 NRS=0.0425 $X=0 $Y=850 $D=42
.ENDS
***************************************
.SUBCKT pmos4_CDNS_7807356271740
** N=4 EP=0 IP=0 FDC=0
.ENDS
***************************************
.SUBCKT ICV_42
** N=6 EP=0 IP=8 FDC=0
.ENDS
***************************************
.SUBCKT ICV_43 1 2 3 5 6
** N=8 EP=5 IP=12 FDC=3
M0 2 5 1 1 pmos4 L=4e-06 W=1.25e-05 AD=1.0625e-11 AS=1.0625e-11 PD=1.42e-05 PS=1.42e-05 NRD=0.034 NRS=0.034 $X=0 $Y=-18050 $D=41
M1 3 6 1 1 pmos4 L=4e-06 W=1.25e-05 AD=1.0625e-11 AS=1.0625e-11 PD=1.42e-05 PS=1.42e-05 NRD=0.034 NRS=0.034 $X=0 $Y=-11750 $D=41
M2 2 5 1 1 pmos4 L=4e-06 W=1.25e-05 AD=1.0625e-11 AS=1.0625e-11 PD=1.42e-05 PS=1.42e-05 NRD=0.034 NRS=0.034 $X=0 $Y=-5450 $D=41
.ENDS
***************************************
.SUBCKT P1_C_CDNS_78073562717157
** N=2 EP=0 IP=0 FDC=0
.ENDS
***************************************
.SUBCKT nmos4_CDNS_7807356271738
** N=3 EP=0 IP=0 FDC=0
.ENDS
***************************************
.SUBCKT ICV_44
** N=5 EP=0 IP=6 FDC=0
.ENDS
***************************************
.SUBCKT pmos4_CDNS_7807356271733 1 2 3 5
** N=5 EP=4 IP=0 FDC=10
M0 2 3 1 5 pmos4 L=4e-06 W=1e-05 AD=5e-12 AS=8.5e-12 PD=1e-06 PS=1.17e-05 NRD=0.0425 NRS=0.0425 $X=0 $Y=850 $D=41
M1 1 3 2 5 pmos4 L=4e-06 W=1e-05 AD=5e-12 AS=5e-12 PD=1e-06 PS=1e-06 NRD=0.0425 NRS=0.0425 $X=0 $Y=5850 $D=41
M2 2 3 1 5 pmos4 L=4e-06 W=1e-05 AD=5e-12 AS=5e-12 PD=1e-06 PS=1e-06 NRD=0.0425 NRS=0.0425 $X=0 $Y=10850 $D=41
M3 1 3 2 5 pmos4 L=4e-06 W=1e-05 AD=5e-12 AS=5e-12 PD=1e-06 PS=1e-06 NRD=0.0425 NRS=0.0425 $X=0 $Y=15850 $D=41
M4 2 3 1 5 pmos4 L=4e-06 W=1e-05 AD=5e-12 AS=5e-12 PD=1e-06 PS=1e-06 NRD=0.0425 NRS=0.0425 $X=0 $Y=20850 $D=41
M5 1 3 2 5 pmos4 L=4e-06 W=1e-05 AD=5e-12 AS=5e-12 PD=1e-06 PS=1e-06 NRD=0.0425 NRS=0.0425 $X=0 $Y=25850 $D=41
M6 2 3 1 5 pmos4 L=4e-06 W=1e-05 AD=5e-12 AS=5e-12 PD=1e-06 PS=1e-06 NRD=0.0425 NRS=0.0425 $X=0 $Y=30850 $D=41
M7 1 3 2 5 pmos4 L=4e-06 W=1e-05 AD=5e-12 AS=5e-12 PD=1e-06 PS=1e-06 NRD=0.0425 NRS=0.0425 $X=0 $Y=35850 $D=41
M8 2 3 1 5 pmos4 L=4e-06 W=1e-05 AD=5e-12 AS=5e-12 PD=1e-06 PS=1e-06 NRD=0.0425 NRS=0.0425 $X=0 $Y=40850 $D=41
M9 1 3 2 5 pmos4 L=4e-06 W=1e-05 AD=8.5e-12 AS=5e-12 PD=1.17e-05 PS=1e-06 NRD=0.0425 NRS=0.0425 $X=0 $Y=45850 $D=41
.ENDS
***************************************
.SUBCKT P1_C_CDNS_78073562717169
** N=2 EP=0 IP=0 FDC=0
.ENDS
***************************************
.SUBCKT pmos4_CDNS_7807356271742
** N=4 EP=0 IP=0 FDC=0
.ENDS
***************************************
.SUBCKT nmos4_CDNS_7807356271725
** N=4 EP=0 IP=0 FDC=0
.ENDS
***************************************
.SUBCKT ICV_45 1 2 5
** N=5 EP=3 IP=8 FDC=1
M0 2 5 1 1 nmos4 L=8e-05 W=8e-06 AD=6.8e-12 AS=6.8e-12 PD=9.7e-06 PS=9.7e-06 NRD=0.053125 NRS=0.053125 $X=-9250 $Y=850 $D=37
.ENDS
***************************************
.SUBCKT ICV_46 1 2 3 4 7
** N=7 EP=5 IP=10 FDC=3
M0 3 7 1 1 nmos4 L=8e-05 W=8e-06 AD=6.8e-12 AS=6.8e-12 PD=9.7e-06 PS=9.7e-06 NRD=0.053125 NRS=0.053125 $X=-18500 $Y=850 $D=37
X1 1 2 7 ICV_45 $T=-18500 0 0 0 $X=-28150 $Y=-250
X2 1 4 7 ICV_45 $T=0 0 0 0 $X=-9650 $Y=-250
.ENDS
***************************************
.SUBCKT nmos4_CDNS_7807356271730 1 2 3 4
** N=4 EP=4 IP=0 FDC=10
M0 2 3 1 4 nmos4 L=4e-06 W=1e-06 AD=5e-13 AS=8.5e-13 PD=1e-06 PS=2.7e-06 NRD=0.425 NRS=0.425 $X=0 $Y=850 $D=37
M1 1 3 2 4 nmos4 L=4e-06 W=1e-06 AD=5e-13 AS=5e-13 PD=1e-06 PS=1e-06 NRD=0.425 NRS=0.425 $X=0 $Y=5850 $D=37
M2 2 3 1 4 nmos4 L=4e-06 W=1e-06 AD=5e-13 AS=5e-13 PD=1e-06 PS=1e-06 NRD=0.425 NRS=0.425 $X=0 $Y=10850 $D=37
M3 1 3 2 4 nmos4 L=4e-06 W=1e-06 AD=5e-13 AS=5e-13 PD=1e-06 PS=1e-06 NRD=0.425 NRS=0.425 $X=0 $Y=15850 $D=37
M4 2 3 1 4 nmos4 L=4e-06 W=1e-06 AD=5e-13 AS=5e-13 PD=1e-06 PS=1e-06 NRD=0.425 NRS=0.425 $X=0 $Y=20850 $D=37
M5 1 3 2 4 nmos4 L=4e-06 W=1e-06 AD=5e-13 AS=5e-13 PD=1e-06 PS=1e-06 NRD=0.425 NRS=0.425 $X=0 $Y=25850 $D=37
M6 2 3 1 4 nmos4 L=4e-06 W=1e-06 AD=5e-13 AS=5e-13 PD=1e-06 PS=1e-06 NRD=0.425 NRS=0.425 $X=0 $Y=30850 $D=37
M7 1 3 2 4 nmos4 L=4e-06 W=1e-06 AD=5e-13 AS=5e-13 PD=1e-06 PS=1e-06 NRD=0.425 NRS=0.425 $X=0 $Y=35850 $D=37
M8 2 3 1 4 nmos4 L=4e-06 W=1e-06 AD=5e-13 AS=5e-13 PD=1e-06 PS=1e-06 NRD=0.425 NRS=0.425 $X=0 $Y=40850 $D=37
M9 1 3 2 4 nmos4 L=4e-06 W=1e-06 AD=8.5e-13 AS=5e-13 PD=2.7e-06 PS=1e-06 NRD=0.425 NRS=0.425 $X=0 $Y=45850 $D=37
.ENDS
***************************************
.SUBCKT ND_C_CDNS_78073562717207
** N=2 EP=0 IP=0 FDC=0
.ENDS
***************************************
.SUBCKT P1_C_CDNS_78073562717162
** N=2 EP=0 IP=0 FDC=0
.ENDS
***************************************
.SUBCKT pmos4_CDNS_7807356271739 1 2 3
** N=4 EP=3 IP=0 FDC=6
M0 2 3 1 1 pmos4 L=4e-06 W=3.335e-05 AD=1.6675e-11 AS=2.83475e-11 PD=1e-06 PS=3.505e-05 NRD=0.0127436 NRS=0.0127436 $X=0 $Y=850 $D=41
M1 1 3 2 1 pmos4 L=4e-06 W=3.335e-05 AD=1.6675e-11 AS=1.6675e-11 PD=1e-06 PS=1e-06 NRD=0.0127436 NRS=0.0127436 $X=0 $Y=5850 $D=41
M2 2 3 1 1 pmos4 L=4e-06 W=3.335e-05 AD=1.6675e-11 AS=1.6675e-11 PD=1e-06 PS=1e-06 NRD=0.0127436 NRS=0.0127436 $X=0 $Y=10850 $D=41
M3 1 3 2 1 pmos4 L=4e-06 W=3.335e-05 AD=1.6675e-11 AS=1.6675e-11 PD=1e-06 PS=1e-06 NRD=0.0127436 NRS=0.0127436 $X=0 $Y=15850 $D=41
M4 2 3 1 1 pmos4 L=4e-06 W=3.335e-05 AD=1.6675e-11 AS=1.6675e-11 PD=1e-06 PS=1e-06 NRD=0.0127436 NRS=0.0127436 $X=0 $Y=20850 $D=41
M5 1 3 2 1 pmos4 L=4e-06 W=3.335e-05 AD=2.83475e-11 AS=1.6675e-11 PD=3.505e-05 PS=1e-06 NRD=0.0127436 NRS=0.0127436 $X=0 $Y=25850 $D=41
.ENDS
***************************************
.SUBCKT rpolyhc_CDNS_7807356271744 1
** N=1 EP=1 IP=0 FDC=1
R0 1 1 L=1.875e-05 W=2e-06 $[rpolyh] $X=600 $Y=0 $D=18
.ENDS
***************************************
.SUBCKT rpolyhc_CDNS_7807356271745 1 2
** N=3 EP=2 IP=0 FDC=1
R0 1 2 L=1.875e-05 W=2e-06 $[rpolyh] $X=600 $Y=0 $D=18
.ENDS
***************************************
.SUBCKT nmos4_CDNS_7807356271737
** N=4 EP=0 IP=0 FDC=0
.ENDS
***************************************
.SUBCKT ICV_47
** N=6 EP=0 IP=8 FDC=0
.ENDS
***************************************
.SUBCKT ICV_48 3 4 5 6
** N=6 EP=4 IP=12 FDC=3
M0 4 6 3 3 nmos4 L=1.2e-05 W=4e-06 AD=3.4e-12 AS=3.4e-12 PD=5.7e-06 PS=5.7e-06 NRD=0.10625 NRS=0.10625 $X=5250 $Y=850 $D=37
M1 5 6 3 3 nmos4 L=1.2e-05 W=4e-06 AD=3.4e-12 AS=3.4e-12 PD=5.7e-06 PS=5.7e-06 NRD=0.10625 NRS=0.10625 $X=10500 $Y=850 $D=37
M2 4 6 3 3 nmos4 L=1.2e-05 W=4e-06 AD=3.4e-12 AS=3.4e-12 PD=5.7e-06 PS=5.7e-06 NRD=0.10625 NRS=0.10625 $X=15750 $Y=850 $D=37
.ENDS
***************************************
.SUBCKT ND_C_CDNS_78073562717175
** N=2 EP=0 IP=0 FDC=0
.ENDS
***************************************
.SUBCKT PD_C_CDNS_78073562717189
** N=1 EP=0 IP=0 FDC=0
.ENDS
***************************************
.SUBCKT nmos4_CDNS_7807356271731 1 2 3 4
** N=4 EP=4 IP=0 FDC=2
M0 2 3 1 4 nmos4 L=3.5e-07 W=1e-05 AD=5e-12 AS=8.5e-12 PD=1e-06 PS=1.17e-05 NRD=0.0425 NRS=0.0425 $X=0 $Y=850 $D=37
M1 1 3 2 4 nmos4 L=3.5e-07 W=1e-05 AD=8.5e-12 AS=5e-12 PD=1.17e-05 PS=1e-06 NRD=0.0425 NRS=0.0425 $X=0 $Y=2200 $D=37
.ENDS
***************************************
.SUBCKT pmos4_CDNS_7807356271732 1 2 3 5
** N=5 EP=4 IP=0 FDC=4
M0 2 3 1 5 pmos4 L=3.5e-07 W=1e-05 AD=5e-12 AS=8.5e-12 PD=1e-06 PS=1.17e-05 NRD=0.0425 NRS=0.0425 $X=0 $Y=850 $D=41
M1 1 3 2 5 pmos4 L=3.5e-07 W=1e-05 AD=5e-12 AS=5e-12 PD=1e-06 PS=1e-06 NRD=0.0425 NRS=0.0425 $X=0 $Y=2200 $D=41
M2 2 3 1 5 pmos4 L=3.5e-07 W=1e-05 AD=5e-12 AS=5e-12 PD=1e-06 PS=1e-06 NRD=0.0425 NRS=0.0425 $X=0 $Y=3550 $D=41
M3 1 3 2 5 pmos4 L=3.5e-07 W=1e-05 AD=8.5e-12 AS=5e-12 PD=1.17e-05 PS=1e-06 NRD=0.0425 NRS=0.0425 $X=0 $Y=4900 $D=41
.ENDS
***************************************
.SUBCKT chopper_f clk clk~ outn outp inn inp VDDA GNDA
** N=8 EP=8 IP=40 FDC=24
X2 inp outp clk GNDA nmos4_CDNS_7807356271731 $T=4700 17650 1 270 $X=1050 $Y=7100
X3 inp outn clk~ GNDA nmos4_CDNS_7807356271731 $T=8700 17650 1 270 $X=5050 $Y=7100
X4 inn outp clk~ GNDA nmos4_CDNS_7807356271731 $T=12700 17650 1 270 $X=9050 $Y=7100
X5 inn outn clk GNDA nmos4_CDNS_7807356271731 $T=16700 17650 1 270 $X=13050 $Y=7100
X6 inp outp clk~ VDDA pmos4_CDNS_7807356271732 $T=27800 16850 1 270 $X=20500 $Y=5650
X7 inp outn clk VDDA pmos4_CDNS_7807356271732 $T=38900 16850 1 270 $X=31600 $Y=5650
X8 inn outp clk VDDA pmos4_CDNS_7807356271732 $T=50000 16850 1 270 $X=42700 $Y=5650
X9 inn outn clk~ VDDA pmos4_CDNS_7807356271732 $T=61100 16850 1 270 $X=53800 $Y=5650
.ENDS
***************************************
.SUBCKT ia_new_f GNDA 2 3 IBIAS 5 6 VDDA 8 VOUT VDDD GNDD VINN EXC1 VINP EXC2 16 17 VREF CLK
** N=42 EP=19 IP=671 FDC=368
R0 6 VOUT L=0.000749802 W=2e-06 $[rpolyh] $X=517300 $Y=211250 $D=17
D1 GNDD VDDD p_nwd AREA=79.6112 PJ=37.4 $X=3125 $Y=315825 $D=87
D2 GNDA VDDA p_nwd AREA=518.32 PJ=108.4 $X=44900 $Y=285500 $D=87
D3 GNDA VDDA p_nwd AREA=518.32 PJ=108.4 $X=45150 $Y=251600 $D=87
D4 GNDA VDDA p_nwd AREA=518.32 PJ=108.4 $X=45450 $Y=325050 $D=87
D5 GNDA GNDA p_nwd AREA=3410.5 PJ=238.6 $X=103400 $Y=296250 $D=87
D6 GNDA 2 p_nwd AREA=1211.92 PJ=139.3 $X=201050 $Y=295350 $D=87
D7 GNDA 3 p_nwd AREA=1211.92 PJ=139.3 $X=201050 $Y=334800 $D=87
D8 GNDA 3 p_nwd AREA=1208.35 PJ=139.1 $X=238100 $Y=295350 $D=87
D9 GNDA 2 p_nwd AREA=1208.35 PJ=139.1 $X=238150 $Y=334800 $D=87
D10 GNDA VDDA p_nwd AREA=5757.57 PJ=368.4 $X=299350 $Y=339700 $D=87
D11 GNDA VDDA p_nwd AREA=2603.69 PJ=274.8 $X=368350 $Y=274500 $D=87
D12 GNDA 8 p_nwd AREA=3679.14 PJ=249.6 $X=403250 $Y=157850 $D=87
D13 GNDA VDDA p_nwd AREA=33264.4 PJ=757.5 $X=504050 $Y=235100 $D=87
D14 GNDA GNDA p_nwd AREA=7246.98 PJ=542.85 $X=512400 $Y=205350 $D=87
D15 GNDA GNDA p_nwd AREA=29284.9 PJ=755.9 $X=752250 $Y=210950 $D=87
M16 31 31 31 GNDA nmos4 L=1.2e-05 W=4e-06 AD=3.4e-12 AS=3.4e-12 PD=5.7e-06 PS=5.7e-06 NRD=0.10625 NRS=0.10625 $X=50300 $Y=168050 $D=38
M17 28 28 28 GNDA nmos4 L=1.2e-05 W=4e-06 AD=3.4e-12 AS=3.4e-12 PD=5.7e-06 PS=5.7e-06 NRD=0.10625 NRS=0.10625 $X=50300 $Y=187750 $D=38
M18 31 31 31 GNDA nmos4 L=1.2e-05 W=4e-06 AD=3.4e-12 AS=3.4e-12 PD=5.7e-06 PS=5.7e-06 NRD=0.10625 NRS=0.10625 $X=97550 $Y=168050 $D=38
M19 28 28 28 GNDA nmos4 L=1.2e-05 W=4e-06 AD=3.4e-12 AS=3.4e-12 PD=5.7e-06 PS=5.7e-06 NRD=0.10625 NRS=0.10625 $X=97550 $Y=187750 $D=38
M20 29 29 29 GNDA nmos4 L=8e-05 W=8e-06 AD=6.8e-12 AS=6.8e-12 PD=9.7e-06 PS=9.7e-06 NRD=0.053125 NRS=0.053125 $X=137300 $Y=168250 $D=38
M21 29 29 29 GNDA nmos4 L=8e-05 W=8e-06 AD=6.8e-12 AS=6.8e-12 PD=9.7e-06 PS=9.7e-06 NRD=0.053125 NRS=0.053125 $X=359300 $Y=168250 $D=38
M22 GNDA GNDA GNDA GNDA nmos4 L=8e-06 W=1e-05 AD=8.5e-12 AS=8.5e-12 PD=1.17e-05 PS=1.17e-05 NRD=0.0425 NRS=0.0425 $X=392275 $Y=224250 $D=38
M23 GNDA GNDA GNDA GNDA nmos4 L=8e-06 W=1e-05 AD=8.5e-12 AS=8.5e-12 PD=1.17e-05 PS=1.17e-05 NRD=0.0425 NRS=0.0425 $X=392275 $Y=236950 $D=38
M24 GNDA GNDA GNDA GNDA nmos4 L=8e-06 W=1e-05 AD=8.5e-12 AS=8.5e-12 PD=1.17e-05 PS=1.17e-05 NRD=0.0425 NRS=0.0425 $X=443775 $Y=224250 $D=38
M25 GNDA GNDA GNDA GNDA nmos4 L=8e-06 W=1e-05 AD=8.5e-12 AS=8.5e-12 PD=1.17e-05 PS=1.17e-05 NRD=0.0425 NRS=0.0425 $X=443775 $Y=236950 $D=38
M26 IBIAS IBIAS 29 GNDA nmos4 L=8e-06 W=2e-05 AD=1.7e-11 AS=1.7e-11 PD=2.17e-05 PS=2.17e-05 NRD=0.02125 NRS=0.02125 $X=6625 $Y=225150 $D=37
M27 26 IBIAS 37 GNDA nmos4 L=8e-06 W=8e-05 AD=6.8e-11 AS=6.8e-11 PD=8.17e-05 PS=8.17e-05 NRD=0.0053125 NRS=0.0053125 $X=27225 $Y=225150 $D=37
M28 GNDA 31 24 GNDA nmos4 L=1.2e-05 W=4e-06 AD=3.4e-12 AS=3.4e-12 PD=5.7e-06 PS=5.7e-06 NRD=0.10625 NRS=0.10625 $X=71300 $Y=168050 $D=37
M29 GNDA 28 22 GNDA nmos4 L=1.2e-05 W=4e-06 AD=3.4e-12 AS=3.4e-12 PD=5.7e-06 PS=5.7e-06 NRD=0.10625 NRS=0.10625 $X=71300 $Y=187750 $D=37
M30 GNDA 31 24 GNDA nmos4 L=1.2e-05 W=4e-06 AD=3.4e-12 AS=3.4e-12 PD=5.7e-06 PS=5.7e-06 NRD=0.10625 NRS=0.10625 $X=92300 $Y=168050 $D=37
M31 GNDA 28 22 GNDA nmos4 L=1.2e-05 W=4e-06 AD=3.4e-12 AS=3.4e-12 PD=5.7e-06 PS=5.7e-06 NRD=0.10625 NRS=0.10625 $X=92300 $Y=187750 $D=37
M32 GNDA 29 31 GNDA nmos4 L=8e-05 W=8e-06 AD=6.8e-12 AS=6.8e-12 PD=9.7e-06 PS=9.7e-06 NRD=0.053125 NRS=0.053125 $X=174300 $Y=168250 $D=37
M33 GNDA 29 31 GNDA nmos4 L=8e-05 W=8e-06 AD=6.8e-12 AS=6.8e-12 PD=9.7e-06 PS=9.7e-06 NRD=0.053125 NRS=0.053125 $X=211300 $Y=168250 $D=37
M34 GNDA 29 29 GNDA nmos4 L=8e-05 W=8e-06 AD=6.8e-12 AS=6.8e-12 PD=9.7e-06 PS=9.7e-06 NRD=0.053125 NRS=0.053125 $X=248300 $Y=168250 $D=37
M35 GNDA 29 31 GNDA nmos4 L=8e-05 W=8e-06 AD=6.8e-12 AS=6.8e-12 PD=9.7e-06 PS=9.7e-06 NRD=0.053125 NRS=0.053125 $X=285300 $Y=168250 $D=37
M36 GNDA 29 31 GNDA nmos4 L=8e-05 W=8e-06 AD=6.8e-12 AS=6.8e-12 PD=9.7e-06 PS=9.7e-06 NRD=0.053125 NRS=0.053125 $X=322300 $Y=168250 $D=37
M37 GNDA 36 36 GNDA nmos4 L=8e-06 W=1e-05 AD=8.5e-12 AS=8.5e-12 PD=1.17e-05 PS=1.17e-05 NRD=0.0425 NRS=0.0425 $X=402575 $Y=224250 $D=37
M38 GNDA 36 5 GNDA nmos4 L=8e-06 W=1e-05 AD=8.5e-12 AS=8.5e-12 PD=1.17e-05 PS=1.17e-05 NRD=0.0425 NRS=0.0425 $X=402575 $Y=236950 $D=37
M39 GNDA 36 5 GNDA nmos4 L=8e-06 W=1e-05 AD=8.5e-12 AS=8.5e-12 PD=1.17e-05 PS=1.17e-05 NRD=0.0425 NRS=0.0425 $X=412875 $Y=224250 $D=37
M40 GNDA 36 36 GNDA nmos4 L=8e-06 W=1e-05 AD=8.5e-12 AS=8.5e-12 PD=1.17e-05 PS=1.17e-05 NRD=0.0425 NRS=0.0425 $X=412875 $Y=236950 $D=37
M41 GNDA 36 36 GNDA nmos4 L=8e-06 W=1e-05 AD=8.5e-12 AS=8.5e-12 PD=1.17e-05 PS=1.17e-05 NRD=0.0425 NRS=0.0425 $X=423175 $Y=224250 $D=37
M42 GNDA 36 5 GNDA nmos4 L=8e-06 W=1e-05 AD=8.5e-12 AS=8.5e-12 PD=1.17e-05 PS=1.17e-05 NRD=0.0425 NRS=0.0425 $X=423175 $Y=236950 $D=37
M43 GNDA 36 5 GNDA nmos4 L=8e-06 W=1e-05 AD=8.5e-12 AS=8.5e-12 PD=1.17e-05 PS=1.17e-05 NRD=0.0425 NRS=0.0425 $X=433475 $Y=224250 $D=37
M44 GNDA 36 36 GNDA nmos4 L=8e-06 W=1e-05 AD=8.5e-12 AS=8.5e-12 PD=1.17e-05 PS=1.17e-05 NRD=0.0425 NRS=0.0425 $X=433475 $Y=236950 $D=37
M45 VOUT 5 GNDA GNDA nmos4 L=2e-06 W=1e-05 AD=8.5e-12 AS=8.5e-12 PD=1.17e-05 PS=1.17e-05 NRD=0.0425 NRS=0.0425 $X=656375 $Y=195900 $D=37
M46 VDDA VDDA VDDA VDDA pmos4 L=2e-05 W=2.5e-05 AD=2.125e-11 AS=2.125e-11 PD=2.67e-05 PS=2.67e-05 NRD=0.017 NRS=0.017 $X=305725 $Y=349100 $D=42
M47 8 8 8 8 pmos4 L=4e-06 W=1.25e-05 AD=1.0625e-11 AS=1.0625e-11 PD=1.42e-05 PS=1.42e-05 NRD=0.034 NRS=0.034 $X=411425 $Y=166150 $D=42
M48 8 8 8 8 pmos4 L=4e-06 W=1.25e-05 AD=1.0625e-11 AS=1.0625e-11 PD=1.42e-05 PS=1.42e-05 NRD=0.034 NRS=0.034 $X=411425 $Y=184750 $D=42
M49 VDDA VDDA VDDA VDDA pmos4 L=2e-05 W=2.5e-05 AD=2.125e-11 AS=2.125e-11 PD=2.67e-05 PS=2.67e-05 NRD=0.017 NRS=0.017 $X=417225 $Y=349100 $D=42
M50 8 8 8 8 pmos4 L=4e-06 W=1.25e-05 AD=1.0625e-11 AS=1.0625e-11 PD=1.42e-05 PS=1.42e-05 NRD=0.034 NRS=0.034 $X=468125 $Y=166150 $D=42
M51 8 8 8 8 pmos4 L=4e-06 W=1.25e-05 AD=1.0625e-11 AS=1.0625e-11 PD=1.42e-05 PS=1.42e-05 NRD=0.034 NRS=0.034 $X=468125 $Y=184750 $D=42
M52 VDDA VDDA VDDA VDDA pmos4 L=1.2e-05 W=1e-05 AD=8.5e-12 AS=8.5e-12 PD=1.17e-05 PS=1.17e-05 NRD=0.0425 NRS=0.0425 $X=539575 $Y=241450 $D=42
M53 VDDA VDDA VDDA VDDA pmos4 L=1.2e-05 W=1e-05 AD=8.5e-12 AS=8.5e-12 PD=1.17e-05 PS=1.17e-05 NRD=0.0425 NRS=0.0425 $X=539575 $Y=356150 $D=42
M54 VDDA VDDA VDDA VDDA pmos4 L=1.2e-05 W=1e-05 AD=8.5e-12 AS=8.5e-12 PD=1.17e-05 PS=1.17e-05 NRD=0.0425 NRS=0.0425 $X=553875 $Y=241450 $D=42
M55 VDDA VDDA VDDA VDDA pmos4 L=1.2e-05 W=1e-05 AD=8.5e-12 AS=8.5e-12 PD=1.17e-05 PS=1.17e-05 NRD=0.0425 NRS=0.0425 $X=553875 $Y=356150 $D=42
M56 VDDA VDDA VDDA VDDA pmos4 L=1.2e-05 W=1e-05 AD=8.5e-12 AS=8.5e-12 PD=1.17e-05 PS=1.17e-05 NRD=0.0425 NRS=0.0425 $X=568175 $Y=241450 $D=42
M57 VDDA VDDA VDDA VDDA pmos4 L=1.2e-05 W=1e-05 AD=8.5e-12 AS=8.5e-12 PD=1.17e-05 PS=1.17e-05 NRD=0.0425 NRS=0.0425 $X=568175 $Y=356150 $D=42
M58 VDDA VDDA VDDA VDDA pmos4 L=1.2e-05 W=1e-05 AD=8.5e-12 AS=8.5e-12 PD=1.17e-05 PS=1.17e-05 NRD=0.0425 NRS=0.0425 $X=582475 $Y=241450 $D=42
M59 VDDA VDDA VDDA VDDA pmos4 L=1.2e-05 W=1e-05 AD=8.5e-12 AS=8.5e-12 PD=1.17e-05 PS=1.17e-05 NRD=0.0425 NRS=0.0425 $X=582475 $Y=356150 $D=42
M60 VDDA VDDA VDDA VDDA pmos4 L=1.2e-05 W=1e-05 AD=8.5e-12 AS=8.5e-12 PD=1.17e-05 PS=1.17e-05 NRD=0.0425 NRS=0.0425 $X=596775 $Y=241450 $D=42
M61 VDDA VDDA VDDA VDDA pmos4 L=1.2e-05 W=1e-05 AD=8.5e-12 AS=8.5e-12 PD=1.17e-05 PS=1.17e-05 NRD=0.0425 NRS=0.0425 $X=596775 $Y=356150 $D=42
M62 VDDA VDDA VDDA VDDA pmos4 L=1.2e-05 W=1e-05 AD=8.5e-12 AS=8.5e-12 PD=1.17e-05 PS=1.17e-05 NRD=0.0425 NRS=0.0425 $X=611075 $Y=241450 $D=42
M63 VDDA VDDA VDDA VDDA pmos4 L=1.2e-05 W=1e-05 AD=8.5e-12 AS=8.5e-12 PD=1.17e-05 PS=1.17e-05 NRD=0.0425 NRS=0.0425 $X=611075 $Y=356150 $D=42
M64 VDDA VDDA VDDA VDDA pmos4 L=1.2e-05 W=1e-05 AD=8.5e-12 AS=8.5e-12 PD=1.17e-05 PS=1.17e-05 NRD=0.0425 NRS=0.0425 $X=625375 $Y=241450 $D=42
M65 VDDA VDDA VDDA VDDA pmos4 L=1.2e-05 W=1e-05 AD=8.5e-12 AS=8.5e-12 PD=1.17e-05 PS=1.17e-05 NRD=0.0425 NRS=0.0425 $X=625375 $Y=356150 $D=42
M66 VDDA VDDA VDDA VDDA pmos4 L=1.2e-05 W=1e-05 AD=8.5e-12 AS=8.5e-12 PD=1.17e-05 PS=1.17e-05 NRD=0.0425 NRS=0.0425 $X=639675 $Y=241450 $D=42
M67 VDDA VDDA VDDA VDDA pmos4 L=1.2e-05 W=1e-05 AD=8.5e-12 AS=8.5e-12 PD=1.17e-05 PS=1.17e-05 NRD=0.0425 NRS=0.0425 $X=639675 $Y=356150 $D=42
M68 VDDA VDDA VDDA VDDA pmos4 L=1.2e-05 W=1e-05 AD=8.5e-12 AS=8.5e-12 PD=1.17e-05 PS=1.17e-05 NRD=0.0425 NRS=0.0425 $X=653975 $Y=241450 $D=42
M69 VDDA VDDA VDDA VDDA pmos4 L=1.2e-05 W=1e-05 AD=8.5e-12 AS=8.5e-12 PD=1.17e-05 PS=1.17e-05 NRD=0.0425 NRS=0.0425 $X=653975 $Y=356150 $D=42
M70 VDDA VDDA VDDA VDDA pmos4 L=1.2e-05 W=1e-05 AD=8.5e-12 AS=8.5e-12 PD=1.17e-05 PS=1.17e-05 NRD=0.0425 NRS=0.0425 $X=668275 $Y=241450 $D=42
M71 VDDA VDDA VDDA VDDA pmos4 L=1.2e-05 W=1e-05 AD=8.5e-12 AS=8.5e-12 PD=1.17e-05 PS=1.17e-05 NRD=0.0425 NRS=0.0425 $X=668275 $Y=356150 $D=42
M72 VDDA VDDA VDDA VDDA pmos4 L=1.2e-05 W=1e-05 AD=8.5e-12 AS=8.5e-12 PD=1.17e-05 PS=1.17e-05 NRD=0.0425 NRS=0.0425 $X=682575 $Y=241450 $D=42
M73 VDDA VDDA VDDA VDDA pmos4 L=1.2e-05 W=1e-05 AD=8.5e-12 AS=8.5e-12 PD=1.17e-05 PS=1.17e-05 NRD=0.0425 NRS=0.0425 $X=682575 $Y=356150 $D=42
M74 VDDA VDDA VDDA VDDA pmos4 L=1.2e-05 W=1e-05 AD=8.5e-12 AS=8.5e-12 PD=1.17e-05 PS=1.17e-05 NRD=0.0425 NRS=0.0425 $X=696875 $Y=241450 $D=42
M75 VDDA VDDA VDDA VDDA pmos4 L=1.2e-05 W=1e-05 AD=8.5e-12 AS=8.5e-12 PD=1.17e-05 PS=1.17e-05 NRD=0.0425 NRS=0.0425 $X=696875 $Y=332850 $D=42
M76 VDDA VDDA VDDA VDDA pmos4 L=1.2e-05 W=1e-05 AD=8.5e-12 AS=8.5e-12 PD=1.17e-05 PS=1.17e-05 NRD=0.0425 NRS=0.0425 $X=696875 $Y=356150 $D=42
M77 VDDA VDDA VDDA VDDA pmos4 L=1.2e-05 W=1e-05 AD=8.5e-12 AS=8.5e-12 PD=1.17e-05 PS=1.17e-05 NRD=0.0425 NRS=0.0425 $X=711175 $Y=241450 $D=42
M78 VDDA VDDA VDDA VDDA pmos4 L=1.2e-05 W=1e-05 AD=8.5e-12 AS=8.5e-12 PD=1.17e-05 PS=1.17e-05 NRD=0.0425 NRS=0.0425 $X=711175 $Y=262950 $D=42
M79 VDDA VDDA VDDA VDDA pmos4 L=1.2e-05 W=1e-05 AD=8.5e-12 AS=8.5e-12 PD=1.17e-05 PS=1.17e-05 NRD=0.0425 NRS=0.0425 $X=711175 $Y=286250 $D=42
M80 VDDA VDDA VDDA VDDA pmos4 L=1.2e-05 W=1e-05 AD=8.5e-12 AS=8.5e-12 PD=1.17e-05 PS=1.17e-05 NRD=0.0425 NRS=0.0425 $X=711175 $Y=309550 $D=42
M81 VDDA VDDA VDDA VDDA pmos4 L=1.2e-05 W=1e-05 AD=8.5e-12 AS=8.5e-12 PD=1.17e-05 PS=1.17e-05 NRD=0.0425 NRS=0.0425 $X=711175 $Y=332850 $D=42
M82 VDDA VDDA VDDA VDDA pmos4 L=1.2e-05 W=1e-05 AD=8.5e-12 AS=8.5e-12 PD=1.17e-05 PS=1.17e-05 NRD=0.0425 NRS=0.0425 $X=711175 $Y=356150 $D=42
M83 VDDA 17 17 VDDA pmos4 L=2e-05 W=2.5e-05 AD=2.125e-11 AS=2.125e-11 PD=2.67e-05 PS=2.67e-05 NRD=0.017 NRS=0.017 $X=328025 $Y=349100 $D=41
M84 VDDA 17 16 VDDA pmos4 L=2e-05 W=2.5e-05 AD=2.125e-11 AS=2.125e-11 PD=2.67e-05 PS=2.67e-05 NRD=0.017 NRS=0.017 $X=350325 $Y=349100 $D=41
M85 VDDA 17 17 VDDA pmos4 L=2e-05 W=2.5e-05 AD=2.125e-11 AS=2.125e-11 PD=2.67e-05 PS=2.67e-05 NRD=0.017 NRS=0.017 $X=372625 $Y=349100 $D=41
M86 VDDA 17 16 VDDA pmos4 L=2e-05 W=2.5e-05 AD=2.125e-11 AS=2.125e-11 PD=2.67e-05 PS=2.67e-05 NRD=0.017 NRS=0.017 $X=394925 $Y=349100 $D=41
M87 8 6 36 8 pmos4 L=4e-06 W=1.25e-05 AD=1.0625e-11 AS=1.0625e-11 PD=1.42e-05 PS=1.42e-05 NRD=0.034 NRS=0.034 $X=436625 $Y=166150 $D=41
M88 8 VREF 5 8 pmos4 L=4e-06 W=1.25e-05 AD=1.0625e-11 AS=1.0625e-11 PD=1.42e-05 PS=1.42e-05 NRD=0.034 NRS=0.034 $X=436625 $Y=184750 $D=41
M89 8 VREF 5 8 pmos4 L=4e-06 W=1.25e-05 AD=1.0625e-11 AS=1.0625e-11 PD=1.42e-05 PS=1.42e-05 NRD=0.034 NRS=0.034 $X=461825 $Y=166150 $D=41
M90 8 6 36 8 pmos4 L=4e-06 W=1.25e-05 AD=1.0625e-11 AS=1.0625e-11 PD=1.42e-05 PS=1.42e-05 NRD=0.034 NRS=0.034 $X=461825 $Y=184750 $D=41
M91 3 26 VDDA VDDA pmos4 L=1.2e-05 W=1e-05 AD=8.5e-12 AS=8.5e-12 PD=1.17e-05 PS=1.17e-05 NRD=0.0425 NRS=0.0425 $X=539575 $Y=262950 $D=41
M92 2 26 VDDA VDDA pmos4 L=1.2e-05 W=1e-05 AD=8.5e-12 AS=8.5e-12 PD=1.17e-05 PS=1.17e-05 NRD=0.0425 NRS=0.0425 $X=539575 $Y=286250 $D=41
M93 3 26 VDDA VDDA pmos4 L=1.2e-05 W=1e-05 AD=8.5e-12 AS=8.5e-12 PD=1.17e-05 PS=1.17e-05 NRD=0.0425 NRS=0.0425 $X=539575 $Y=309550 $D=41
M94 2 26 VDDA VDDA pmos4 L=1.2e-05 W=1e-05 AD=8.5e-12 AS=8.5e-12 PD=1.17e-05 PS=1.17e-05 NRD=0.0425 NRS=0.0425 $X=539575 $Y=332850 $D=41
M95 2 26 VDDA VDDA pmos4 L=1.2e-05 W=1e-05 AD=8.5e-12 AS=8.5e-12 PD=1.17e-05 PS=1.17e-05 NRD=0.0425 NRS=0.0425 $X=553875 $Y=262950 $D=41
M96 3 26 VDDA VDDA pmos4 L=1.2e-05 W=1e-05 AD=8.5e-12 AS=8.5e-12 PD=1.17e-05 PS=1.17e-05 NRD=0.0425 NRS=0.0425 $X=553875 $Y=286250 $D=41
M97 2 26 VDDA VDDA pmos4 L=1.2e-05 W=1e-05 AD=8.5e-12 AS=8.5e-12 PD=1.17e-05 PS=1.17e-05 NRD=0.0425 NRS=0.0425 $X=553875 $Y=309550 $D=41
M98 3 26 VDDA VDDA pmos4 L=1.2e-05 W=1e-05 AD=8.5e-12 AS=8.5e-12 PD=1.17e-05 PS=1.17e-05 NRD=0.0425 NRS=0.0425 $X=553875 $Y=332850 $D=41
M99 VOUT 26 VDDA VDDA pmos4 L=1.2e-05 W=1e-05 AD=8.5e-12 AS=8.5e-12 PD=1.17e-05 PS=1.17e-05 NRD=0.0425 NRS=0.0425 $X=568175 $Y=262950 $D=41
M100 2 26 VDDA VDDA pmos4 L=1.2e-05 W=1e-05 AD=8.5e-12 AS=8.5e-12 PD=1.17e-05 PS=1.17e-05 NRD=0.0425 NRS=0.0425 $X=568175 $Y=286250 $D=41
M101 3 26 VDDA VDDA pmos4 L=1.2e-05 W=1e-05 AD=8.5e-12 AS=8.5e-12 PD=1.17e-05 PS=1.17e-05 NRD=0.0425 NRS=0.0425 $X=568175 $Y=309550 $D=41
M102 2 26 VDDA VDDA pmos4 L=1.2e-05 W=1e-05 AD=8.5e-12 AS=8.5e-12 PD=1.17e-05 PS=1.17e-05 NRD=0.0425 NRS=0.0425 $X=568175 $Y=332850 $D=41
M103 VOUT 26 VDDA VDDA pmos4 L=1.2e-05 W=1e-05 AD=8.5e-12 AS=8.5e-12 PD=1.17e-05 PS=1.17e-05 NRD=0.0425 NRS=0.0425 $X=582475 $Y=262950 $D=41
M104 26 26 VDDA VDDA pmos4 L=1.2e-05 W=1e-05 AD=8.5e-12 AS=8.5e-12 PD=1.17e-05 PS=1.17e-05 NRD=0.0425 NRS=0.0425 $X=582475 $Y=286250 $D=41
M105 2 26 VDDA VDDA pmos4 L=1.2e-05 W=1e-05 AD=8.5e-12 AS=8.5e-12 PD=1.17e-05 PS=1.17e-05 NRD=0.0425 NRS=0.0425 $X=582475 $Y=309550 $D=41
M106 3 26 VDDA VDDA pmos4 L=1.2e-05 W=1e-05 AD=8.5e-12 AS=8.5e-12 PD=1.17e-05 PS=1.17e-05 NRD=0.0425 NRS=0.0425 $X=582475 $Y=332850 $D=41
M107 VOUT 26 VDDA VDDA pmos4 L=1.2e-05 W=1e-05 AD=8.5e-12 AS=8.5e-12 PD=1.17e-05 PS=1.17e-05 NRD=0.0425 NRS=0.0425 $X=596775 $Y=262950 $D=41
M108 2 26 VDDA VDDA pmos4 L=1.2e-05 W=1e-05 AD=8.5e-12 AS=8.5e-12 PD=1.17e-05 PS=1.17e-05 NRD=0.0425 NRS=0.0425 $X=596775 $Y=286250 $D=41
M109 8 26 VDDA VDDA pmos4 L=1.2e-05 W=1e-05 AD=8.5e-12 AS=8.5e-12 PD=1.17e-05 PS=1.17e-05 NRD=0.0425 NRS=0.0425 $X=596775 $Y=309550 $D=41
M110 2 26 VDDA VDDA pmos4 L=1.2e-05 W=1e-05 AD=8.5e-12 AS=8.5e-12 PD=1.17e-05 PS=1.17e-05 NRD=0.0425 NRS=0.0425 $X=596775 $Y=332850 $D=41
M111 VOUT 26 VDDA VDDA pmos4 L=1.2e-05 W=1e-05 AD=8.5e-12 AS=8.5e-12 PD=1.17e-05 PS=1.17e-05 NRD=0.0425 NRS=0.0425 $X=611075 $Y=262950 $D=41
M112 3 26 VDDA VDDA pmos4 L=1.2e-05 W=1e-05 AD=8.5e-12 AS=8.5e-12 PD=1.17e-05 PS=1.17e-05 NRD=0.0425 NRS=0.0425 $X=611075 $Y=286250 $D=41
M113 8 26 VDDA VDDA pmos4 L=1.2e-05 W=1e-05 AD=8.5e-12 AS=8.5e-12 PD=1.17e-05 PS=1.17e-05 NRD=0.0425 NRS=0.0425 $X=611075 $Y=309550 $D=41
M114 3 26 VDDA VDDA pmos4 L=1.2e-05 W=1e-05 AD=8.5e-12 AS=8.5e-12 PD=1.17e-05 PS=1.17e-05 NRD=0.0425 NRS=0.0425 $X=611075 $Y=332850 $D=41
M115 VOUT 26 VDDA VDDA pmos4 L=1.2e-05 W=1e-05 AD=8.5e-12 AS=8.5e-12 PD=1.17e-05 PS=1.17e-05 NRD=0.0425 NRS=0.0425 $X=625375 $Y=262950 $D=41
M116 2 26 VDDA VDDA pmos4 L=1.2e-05 W=1e-05 AD=8.5e-12 AS=8.5e-12 PD=1.17e-05 PS=1.17e-05 NRD=0.0425 NRS=0.0425 $X=625375 $Y=286250 $D=41
M117 8 26 VDDA VDDA pmos4 L=1.2e-05 W=1e-05 AD=8.5e-12 AS=8.5e-12 PD=1.17e-05 PS=1.17e-05 NRD=0.0425 NRS=0.0425 $X=625375 $Y=309550 $D=41
M118 2 26 VDDA VDDA pmos4 L=1.2e-05 W=1e-05 AD=8.5e-12 AS=8.5e-12 PD=1.17e-05 PS=1.17e-05 NRD=0.0425 NRS=0.0425 $X=625375 $Y=332850 $D=41
M119 VOUT 26 VDDA VDDA pmos4 L=1.2e-05 W=1e-05 AD=8.5e-12 AS=8.5e-12 PD=1.17e-05 PS=1.17e-05 NRD=0.0425 NRS=0.0425 $X=639675 $Y=262950 $D=41
M120 3 26 VDDA VDDA pmos4 L=1.2e-05 W=1e-05 AD=8.5e-12 AS=8.5e-12 PD=1.17e-05 PS=1.17e-05 NRD=0.0425 NRS=0.0425 $X=639675 $Y=286250 $D=41
M121 8 26 VDDA VDDA pmos4 L=1.2e-05 W=1e-05 AD=8.5e-12 AS=8.5e-12 PD=1.17e-05 PS=1.17e-05 NRD=0.0425 NRS=0.0425 $X=639675 $Y=309550 $D=41
M122 3 26 VDDA VDDA pmos4 L=1.2e-05 W=1e-05 AD=8.5e-12 AS=8.5e-12 PD=1.17e-05 PS=1.17e-05 NRD=0.0425 NRS=0.0425 $X=639675 $Y=332850 $D=41
M123 VOUT 26 VDDA VDDA pmos4 L=1.2e-05 W=1e-05 AD=8.5e-12 AS=8.5e-12 PD=1.17e-05 PS=1.17e-05 NRD=0.0425 NRS=0.0425 $X=653975 $Y=262950 $D=41
M124 2 26 VDDA VDDA pmos4 L=1.2e-05 W=1e-05 AD=8.5e-12 AS=8.5e-12 PD=1.17e-05 PS=1.17e-05 NRD=0.0425 NRS=0.0425 $X=653975 $Y=286250 $D=41
M125 8 26 VDDA VDDA pmos4 L=1.2e-05 W=1e-05 AD=8.5e-12 AS=8.5e-12 PD=1.17e-05 PS=1.17e-05 NRD=0.0425 NRS=0.0425 $X=653975 $Y=309550 $D=41
M126 3 26 VDDA VDDA pmos4 L=1.2e-05 W=1e-05 AD=8.5e-12 AS=8.5e-12 PD=1.17e-05 PS=1.17e-05 NRD=0.0425 NRS=0.0425 $X=653975 $Y=332850 $D=41
M127 VOUT 26 VDDA VDDA pmos4 L=1.2e-05 W=1e-05 AD=8.5e-12 AS=8.5e-12 PD=1.17e-05 PS=1.17e-05 NRD=0.0425 NRS=0.0425 $X=668275 $Y=262950 $D=41
M128 3 26 VDDA VDDA pmos4 L=1.2e-05 W=1e-05 AD=8.5e-12 AS=8.5e-12 PD=1.17e-05 PS=1.17e-05 NRD=0.0425 NRS=0.0425 $X=668275 $Y=286250 $D=41
M129 26 26 VDDA VDDA pmos4 L=1.2e-05 W=1e-05 AD=8.5e-12 AS=8.5e-12 PD=1.17e-05 PS=1.17e-05 NRD=0.0425 NRS=0.0425 $X=668275 $Y=309550 $D=41
M130 3 26 VDDA VDDA pmos4 L=1.2e-05 W=1e-05 AD=8.5e-12 AS=8.5e-12 PD=1.17e-05 PS=1.17e-05 NRD=0.0425 NRS=0.0425 $X=668275 $Y=332850 $D=41
M131 VOUT 26 VDDA VDDA pmos4 L=1.2e-05 W=1e-05 AD=8.5e-12 AS=8.5e-12 PD=1.17e-05 PS=1.17e-05 NRD=0.0425 NRS=0.0425 $X=682575 $Y=262950 $D=41
M132 2 26 VDDA VDDA pmos4 L=1.2e-05 W=1e-05 AD=8.5e-12 AS=8.5e-12 PD=1.17e-05 PS=1.17e-05 NRD=0.0425 NRS=0.0425 $X=682575 $Y=286250 $D=41
M133 3 26 VDDA VDDA pmos4 L=1.2e-05 W=1e-05 AD=8.5e-12 AS=8.5e-12 PD=1.17e-05 PS=1.17e-05 NRD=0.0425 NRS=0.0425 $X=682575 $Y=309550 $D=41
M134 2 26 VDDA VDDA pmos4 L=1.2e-05 W=1e-05 AD=8.5e-12 AS=8.5e-12 PD=1.17e-05 PS=1.17e-05 NRD=0.0425 NRS=0.0425 $X=682575 $Y=332850 $D=41
M135 VOUT 26 VDDA VDDA pmos4 L=1.2e-05 W=1e-05 AD=8.5e-12 AS=8.5e-12 PD=1.17e-05 PS=1.17e-05 NRD=0.0425 NRS=0.0425 $X=696875 $Y=262950 $D=41
M136 3 26 VDDA VDDA pmos4 L=1.2e-05 W=1e-05 AD=8.5e-12 AS=8.5e-12 PD=1.17e-05 PS=1.17e-05 NRD=0.0425 NRS=0.0425 $X=696875 $Y=286250 $D=41
M137 2 26 VDDA VDDA pmos4 L=1.2e-05 W=1e-05 AD=8.5e-12 AS=8.5e-12 PD=1.17e-05 PS=1.17e-05 NRD=0.0425 NRS=0.0425 $X=696875 $Y=309550 $D=41
C138 GNDA IBIAS $[cpolya] $A=1080 $P=156 $X=10850 $Y=143000 $D=58
C139 VOUT 5 $[cpolya] $A=2306.26 $P=192.1 $X=585325 $Y=152300 $D=58
X140 VDDD 21 CLK pmos4_CDNS_7807356271735 $T=4325 318425 0 270 $X=3125 $Y=315825
X141 VDDD 23 21 pmos4_CDNS_7807356271735 $T=11925 318425 0 270 $X=10725 $Y=315825
X142 GNDD 21 CLK nmos4_CDNS_7807356271734 $T=4325 312825 0 270 $X=4075 $Y=311625
X143 GNDD 23 21 nmos4_CDNS_7807356271734 $T=11925 312925 0 270 $X=11675 $Y=311725
X144 VOUT 6 cpolyc_CDNS_7807356271736 $T=753600 212300 0 0 $X=752250 $Y=210950
X145 VOUT 6 cpolyc_CDNS_7807356271736 $T=753600 268600 0 0 $X=752250 $Y=267250
X146 VOUT 6 cpolyc_CDNS_7807356271736 $T=753600 324900 0 0 $X=752250 $Y=323550
X147 VOUT 6 cpolyc_CDNS_7807356271736 $T=810600 212300 0 0 $X=809250 $Y=210950
X148 VOUT 6 cpolyc_CDNS_7807356271736 $T=810600 268600 0 0 $X=809250 $Y=267250
X149 VOUT 6 cpolyc_CDNS_7807356271736 $T=810600 324900 0 0 $X=809250 $Y=323550
X150 VOUT 6 cpolyc_CDNS_7807356271736 $T=867600 212300 0 0 $X=866250 $Y=210950
X151 VOUT 6 cpolyc_CDNS_7807356271736 $T=867600 268600 0 0 $X=866250 $Y=267250
X152 VOUT 6 cpolyc_CDNS_7807356271736 $T=867600 324900 0 0 $X=866250 $Y=323550
X153 40 rpolyhc_CDNS_7807356271747 $T=641750 150250 0 0 $X=637750 $Y=146800
X154 41 rpolyhc_CDNS_7807356271747 $T=765550 195750 0 0 $X=761550 $Y=192300
X155 42 rpolyhc_CDNS_7807356271747 $T=840150 195200 0 0 $X=836150 $Y=191750
X252 VDDA ICV_41 $T=524425 251450 0 270 $X=523225 $Y=240250
X253 VDDA ICV_41 $T=524425 272950 0 270 $X=523225 $Y=261750
X254 VDDA ICV_41 $T=524425 296250 0 270 $X=523225 $Y=285050
X255 VDDA ICV_41 $T=524425 319550 0 270 $X=523225 $Y=308350
X256 VDDA ICV_41 $T=524425 342850 0 270 $X=523225 $Y=331650
X257 VDDA ICV_41 $T=524425 366150 0 270 $X=523225 $Y=354950
X260 8 5 36 VREF 6 ICV_43 $T=416275 166150 0 90 $X=409375 $Y=164950
X261 8 36 5 6 VREF ICV_43 $T=416275 184750 0 90 $X=409375 $Y=183550
X262 8 36 5 6 VREF ICV_43 $T=441475 166150 0 90 $X=434575 $Y=164950
X263 8 5 36 VREF 6 ICV_43 $T=441475 184750 0 90 $X=434575 $Y=183550
X276 16 6 35 VDDA pmos4_CDNS_7807356271733 $T=374675 290850 0 270 $X=373475 $Y=279650
X277 17 35 35 VDDA pmos4_CDNS_7807356271733 $T=425975 290850 0 270 $X=424775 $Y=279650
X291 GNDA 28 31 37 29 ICV_46 $T=145300 249100 0 180 $X=136900 $Y=167150
X292 GNDA 28 31 28 29 ICV_46 $T=182300 249100 0 180 $X=173900 $Y=167150
X293 GNDA 28 31 28 29 ICV_46 $T=219300 249100 0 180 $X=210900 $Y=167150
X294 GNDA 28 31 28 29 ICV_46 $T=256300 249100 0 180 $X=247900 $Y=167150
X295 GNDA 28 31 28 29 ICV_46 $T=293300 249100 0 180 $X=284900 $Y=167150
X296 GNDA 37 31 28 29 ICV_46 $T=330300 249100 0 180 $X=321900 $Y=167150
X297 25 6 IBIAS GNDA nmos4_CDNS_7807356271730 $T=351425 276550 0 90 $X=300475 $Y=275750
X298 32 2 IBIAS GNDA nmos4_CDNS_7807356271730 $T=351425 284650 0 90 $X=300475 $Y=283850
X299 34 35 IBIAS GNDA nmos4_CDNS_7807356271730 $T=351425 292750 0 90 $X=300475 $Y=291950
X300 33 3 IBIAS GNDA nmos4_CDNS_7807356271730 $T=351425 300850 0 90 $X=300475 $Y=300050
X313 2 28 38 pmos4_CDNS_7807356271739 $T=233300 296550 0 90 $X=201400 $Y=295350
X314 3 31 39 pmos4_CDNS_7807356271739 $T=233300 369350 1 270 $X=201400 $Y=334800
X315 3 31 39 pmos4_CDNS_7807356271739 $T=270400 296550 0 90 $X=238500 $Y=295350
X316 2 28 38 pmos4_CDNS_7807356271739 $T=270400 369350 1 270 $X=238500 $Y=334800
X317 GNDA rpolyhc_CDNS_7807356271744 $T=112150 303550 0 0 $X=104950 $Y=297800
X318 GNDA rpolyhc_CDNS_7807356271744 $T=112150 334450 0 0 $X=104950 $Y=328700
X319 GNDA rpolyhc_CDNS_7807356271744 $T=146500 303550 0 0 $X=139300 $Y=297800
X320 GNDA rpolyhc_CDNS_7807356271744 $T=146500 334450 0 0 $X=139300 $Y=328700
X321 27 3 rpolyhc_CDNS_7807356271745 $T=114550 314650 0 0 $X=109750 $Y=311300
X322 27 3 rpolyhc_CDNS_7807356271745 $T=114550 323350 0 0 $X=109750 $Y=320000
X323 2 30 rpolyhc_CDNS_7807356271745 $T=144100 314650 0 0 $X=139300 $Y=311300
X324 2 30 rpolyhc_CDNS_7807356271745 $T=144100 323350 0 0 $X=139300 $Y=320000
X327 GNDA 33 24 31 ICV_48 $T=50300 180900 1 0 $X=49900 $Y=166950
X328 GNDA 32 22 28 ICV_48 $T=50300 200600 1 0 $X=49900 $Y=186650
X329 GNDA 33 24 31 ICV_48 $T=71300 180900 1 0 $X=70900 $Y=166950
X330 GNDA 32 22 28 ICV_48 $T=71300 200600 1 0 $X=70900 $Y=186650
X336 23 21 22 24 25 34 VDDA GNDA chopper_f $T=24400 279850 0 0 $X=21150 $Y=280350
X337 23 21 EXC2 EXC1 30 27 VDDA GNDA chopper_f $T=24650 245950 0 0 $X=21400 $Y=246450
X338 23 21 38 39 VINP VINN VDDA GNDA chopper_f $T=24950 319400 0 0 $X=21700 $Y=319900
.ENDS
***************************************
.SUBCKT ECG_Front_End VINP VINN F<0> F<1> F<2> VREF_CM CM EN_CMFB VDDA GNDA BIAS7 BIAS4 S<0> CVGA S<1> S<2> CMFB S<3> VDDD EXC1
+ EXC2 CBUF BIAS6 OUT GNDD VREF BIAS1 CLK BIAS2 BIAS3 BIAS5
** N=74 EP=31 IP=148 FDC=2505
D0 GNDA VDDA p_nwd AREA=165.435 PJ=66.1 $X=411150 $Y=904300 $D=87
D1 GNDA VDDA p_nwd AREA=163.68 PJ=65.2 $X=411650 $Y=602950 $D=87
D2 GNDA VDDA p_nwd AREA=160.43 PJ=64.8 $X=1451050 $Y=603050 $D=87
X3 VDDA GNDA V500_20 $T=91650 76950 1 0 $X=91450 $Y=52850
X4 VDDA GNDA V500_20 $T=345350 348700 0 0 $X=345150 $Y=348650
X5 VDDA GNDA V500_20 $T=347650 675300 1 0 $X=347450 $Y=651200
X6 VDDA GNDA V500_20 $T=352250 955950 0 0 $X=352050 $Y=955900
X7 VDDA GNDA V500_20 $T=591650 76950 1 0 $X=591450 $Y=52850
X8 VDDA GNDA V500_20 $T=1146050 108550 1 0 $X=1145850 $Y=84450
X9 VDDA GNDA V500_20 $T=1214600 904850 0 0 $X=1214400 $Y=904800
X10 VDDA GNDA V500_20 $T=1223900 675300 1 0 $X=1223700 $Y=651200
X11 VDDA GNDA V500_20 $T=1235050 76950 1 0 $X=1234850 $Y=52850
X12 VDDA GNDA V500_20 $T=1248900 348700 0 0 $X=1248700 $Y=348650
X13 VDDA GNDA V500_20 $T=1256350 955950 0 0 $X=1256150 $Y=955900
X14 VDDA GNDA V500_20 $T=2132925 608050 0 270 $X=2132875 $Y=113550
X15 VDDA GNDA V200_20 $T=1026825 324425 0 270 $X=1026775 $Y=124375
X16 VDDA GNDA V200_20 $T=1089925 610275 0 270 $X=1089875 $Y=410225
X17 VDDA GNDA V200_20 $T=1089925 903025 0 270 $X=1089875 $Y=702975
X18 VDDA GNDA V200_20 $T=1653025 321325 0 270 $X=1652975 $Y=121275
X19 VDDA GNDA V200_20 $T=1776375 888125 0 270 $X=1776325 $Y=688075
X20 VDDA GNDA V200_20 $T=1797600 83100 0 0 $X=1797650 $Y=83050
X21 VDDA GNDA V200_20 $T=2036325 321375 0 270 $X=2036275 $Y=121325
X22 VDDA GNDA V200_20 $T=2080475 310775 0 270 $X=2080425 $Y=110725
X23 VDDA OUT 35 CBUF BIAS6 GNDA BUFFER $T=1672800 105125 0 0 $X=1683000 $Y=116998
X24 6 VDDA 41 BIAS4 GNDA 10 S<0> CVGA 61 S<1> S<2> 42 S<3> VGA_1 $T=1120800 700050 0 0 $X=1123225 $Y=683498
X25 53 11 VDDA 12 52 BIAS2 17 15 F<0> 19 21 23 GNDA 31 10 F<1> F<2> Gm_C_filter $T=56325 661900 0 0 $X=83850 $Y=382748
X26 55 13 VDDA 14 54 BIAS3 18 10 F<0> 20 22 24 GNDA 15 10 F<1> F<2> Gm_C_filter $T=56325 963150 0 0 $X=83850 $Y=683998
X27 60 33 VDDA 34 59 BIAS5 36 35 F<0> 38 39 40 GNDA 6 35 F<1> F<2> Gm_C_filter $T=1095700 661900 0 0 $X=1123225 $Y=382748
X28 CM VREF_CM EN_CMFB BIAS7 VDDA GNDA VINP VINN CMFB 58 fecg_cmfb2_fc $T=1058300 128700 0 0 $X=1066550 $Y=134548
X29 GNDA 28 26 BIAS1 29 27 VDDA 30 31 VDDD GNDD VINN EXC1 VINP EXC2 56 57 VREF CLK ia_new_f $T=92600 -53150 0 0 $X=90200 $Y=79050
.ENDS
***************************************
