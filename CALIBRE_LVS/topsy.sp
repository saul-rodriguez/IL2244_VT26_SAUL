* SPICE NETLIST
***************************************

.SUBCKT tsv80 TOP BOTTOM SUB
.ENDS
***************************************
.SUBCKT rx POS NEG
.ENDS
***************************************
.SUBCKT Q C B E S G
.ENDS
***************************************
.SUBCKT lddn D G S B
.ENDS
***************************************
.SUBCKT phd POS NEG P
.ENDS
***************************************
.SUBCKT sbd A C SUB
.ENDS
***************************************
.SUBCKT esddlv2 A C
.ENDS
***************************************
.SUBCKT esddlv A C SUB
.ENDS
***************************************
.SUBCKT lddp D G S B
.ENDS
***************************************
.SUBCKT probepad pad
.ENDS
***************************************
.SUBCKT L POS NEG SUB
.ENDS
***************************************
.SUBCKT L POS NEG MID SUB
.ENDS
***************************************
.SUBCKT hall A B C D S P1 P2
.ENDS
***************************************
.SUBCKT PERI_SPACER_2_P
** N=6 EP=0 IP=0 FDC=0
.ENDS
***************************************
.SUBCKT PERI_SPACER_5_P
** N=6 EP=0 IP=0 FDC=0
.ENDS
***************************************
.SUBCKT PERI_SPACER_10_P
** N=6 EP=0 IP=0 FDC=0
.ENDS
***************************************
.SUBCKT g_padonly_0
** N=1 EP=0 IP=0 FDC=0
.ENDS
***************************************
.SUBCKT ICP vdd3r2! gnd3r! vdd3r1! gnd3o! vdd3o! PAD Y
** N=12 EP=7 IP=1 FDC=52
R0 10 PAD L=4.70674e-05 W=8e-07 $[rpoly1] $X=89850 $Y=259725 $D=8
R1 12 gnd3o! L=1.57e-05 W=1.6e-06 $SUB=vdd3o! $[rdiffp3] $X=26300 $Y=167850 $D=29
R2 vdd3o! 11 L=1.57e-05 W=1.6e-06 $SUB=vdd3o! $[rdiffp3] $X=57900 $Y=167850 $D=29
D3 gnd3r! 10 nd AREA=7.5 PJ=10.2284 $X=88800 $Y=285150 $D=63
D4 10 vdd3r2! pd AREA=6.4 PJ=9.42843 $X=88800 $Y=272000 $D=64
D5 gnd3r! vdd3r2! nwd AREA=2395.9 PJ=195.1 $X=1500 $Y=256750 $D=65
D6 gnd3r! vdd3r1! nwd AREA=1910.9 PJ=195.1 $X=1500 $Y=313700 $D=65
D7 gnd3o! vdd3o! nwd AREA=866.32 PJ=448.6 $X=1500 $Y=99800 $D=65
D8 gnd3o! PAD nwd AREA=200.4 PJ=98.4569 $X=14350 $Y=111600 $D=65
D9 gnd3o! PAD nwd AREA=200.4 PJ=98.4569 $X=31050 $Y=111600 $D=65
D10 gnd3o! PAD nwd AREA=200.4 PJ=98.4569 $X=47750 $Y=111600 $D=65
D11 gnd3o! PAD nwd AREA=200.4 PJ=98.4569 $X=64450 $Y=111600 $D=65
D12 gnd3o! PAD nwd AREA=200.4 PJ=98.4569 $X=81150 $Y=111600 $D=65
D13 12 vdd3o! p_pd AREA=1.12 PJ=3 $X=25600 $Y=167850 $D=86
D14 gnd3o! vdd3o! p_pd AREA=1.12 PJ=3 $X=42000 $Y=167850 $D=86
D15 vdd3o! vdd3o! p_pd AREA=1.12 PJ=3 $X=57200 $Y=167850 $D=86
D16 11 vdd3o! p_pd AREA=1.12 PJ=3 $X=73600 $Y=167850 $D=86
D17 gnd3o! vdd3o! p_nwd AREA=6918.4 PJ=334.4 $X=4000 $Y=176500 $D=87
D18 gnd3o! vdd3o! p_nwd AREA=222.017 PJ=61.8728 $X=22850 $Y=167400 $D=87
M19 PAD 12 gnd3o! gnd3o! nmos4 L=5.5e-07 W=5e-05 AD=2.6375e-10 AS=9.375e-11 PD=1.055e-05 PS=5.375e-05 NRD=0.0085 NRS=0.0085 $X=10725 $Y=108600 $D=37
M20 gnd3o! 12 PAD gnd3o! nmos4 L=5.5e-07 W=5e-05 AD=9.625e-11 AS=2.6375e-10 PD=5.385e-05 PS=1.055e-05 NRD=0.0085 NRS=0.0085 $X=21825 $Y=108600 $D=37
M21 PAD 12 gnd3o! gnd3o! nmos4 L=5.5e-07 W=5e-05 AD=2.6375e-10 AS=9.625e-11 PD=1.055e-05 PS=5.385e-05 NRD=0.0085 NRS=0.0085 $X=27425 $Y=108600 $D=37
M22 gnd3o! 12 PAD gnd3o! nmos4 L=5.5e-07 W=5e-05 AD=9.625e-11 AS=2.6375e-10 PD=5.385e-05 PS=1.055e-05 NRD=0.0085 NRS=0.0085 $X=38525 $Y=108600 $D=37
M23 PAD 12 gnd3o! gnd3o! nmos4 L=5.5e-07 W=5e-05 AD=2.6375e-10 AS=9.625e-11 PD=1.055e-05 PS=5.385e-05 NRD=0.0085 NRS=0.0085 $X=44125 $Y=108600 $D=37
M24 gnd3o! 12 PAD gnd3o! nmos4 L=5.5e-07 W=5e-05 AD=9.625e-11 AS=2.6375e-10 PD=5.385e-05 PS=1.055e-05 NRD=0.0085 NRS=0.0085 $X=55225 $Y=108600 $D=37
M25 PAD 12 gnd3o! gnd3o! nmos4 L=5.5e-07 W=5e-05 AD=2.6375e-10 AS=9.625e-11 PD=1.055e-05 PS=5.385e-05 NRD=0.0085 NRS=0.0085 $X=60825 $Y=108600 $D=37
M26 gnd3o! 12 PAD gnd3o! nmos4 L=5.5e-07 W=5e-05 AD=9.625e-11 AS=2.6375e-10 PD=5.385e-05 PS=1.055e-05 NRD=0.0085 NRS=0.0085 $X=71925 $Y=108600 $D=37
M27 PAD 12 gnd3o! gnd3o! nmos4 L=5.5e-07 W=5e-05 AD=2.6375e-10 AS=9.625e-11 PD=1.055e-05 PS=5.385e-05 NRD=0.0085 NRS=0.0085 $X=77525 $Y=108600 $D=37
M28 gnd3r! 9 Y gnd3r! nmos4 L=3.5e-07 W=8e-06 AD=7.72e-12 AS=8.6e-12 PD=7.12e-06 PS=1.015e-05 NRD=0.053125 NRS=0.053125 $X=79125 $Y=296400 $D=37
M29 9 10 gnd3r! gnd3r! nmos4 L=3.5e-07 W=2e-06 AD=2.45e-12 AS=1.93e-12 PD=4.45e-06 PS=1.78e-06 NRD=0.2125 NRS=0.2125 $X=80925 $Y=298750 $D=37
M30 gnd3o! 12 PAD gnd3o! nmos4 L=5.5e-07 W=5e-05 AD=9.375e-11 AS=2.6375e-10 PD=5.375e-05 PS=1.055e-05 NRD=0.0085 NRS=0.0085 $X=88625 $Y=108600 $D=37
M31 PAD 11 vdd3o! vdd3o! pmos4 L=5.5e-07 W=6.6e-05 AD=1.3365e-10 AS=1.2705e-10 PD=4.05e-06 PS=6.985e-05 NRD=0.00643939 NRS=0.00643939 $X=11375 $Y=181100 $D=41
M32 vdd3o! 11 PAD vdd3o! pmos4 L=5.5e-07 W=6.6e-05 AD=1.3035e-10 AS=1.3365e-10 PD=6.995e-05 PS=4.05e-06 NRD=0.00643939 NRS=0.00643939 $X=15975 $Y=181100 $D=41
M33 PAD 11 vdd3o! vdd3o! pmos4 L=5.5e-07 W=6.6e-05 AD=1.3365e-10 AS=1.3035e-10 PD=4.05e-06 PS=6.995e-05 NRD=0.00643939 NRS=0.00643939 $X=21675 $Y=181100 $D=41
M34 vdd3o! 11 PAD vdd3o! pmos4 L=5.5e-07 W=6.6e-05 AD=1.3035e-10 AS=1.3365e-10 PD=6.995e-05 PS=4.05e-06 NRD=0.00643939 NRS=0.00643939 $X=26275 $Y=181100 $D=41
M35 PAD 11 vdd3o! vdd3o! pmos4 L=5.5e-07 W=6.6e-05 AD=1.3365e-10 AS=1.3035e-10 PD=4.05e-06 PS=6.995e-05 NRD=0.00643939 NRS=0.00643939 $X=31975 $Y=181100 $D=41
M36 vdd3o! 11 PAD vdd3o! pmos4 L=5.5e-07 W=6.6e-05 AD=1.3035e-10 AS=1.3365e-10 PD=6.995e-05 PS=4.05e-06 NRD=0.00643939 NRS=0.00643939 $X=36575 $Y=181100 $D=41
M37 PAD 11 vdd3o! vdd3o! pmos4 L=5.5e-07 W=6.6e-05 AD=1.3365e-10 AS=1.3035e-10 PD=4.05e-06 PS=6.995e-05 NRD=0.00643939 NRS=0.00643939 $X=42275 $Y=181100 $D=41
M38 vdd3o! 11 PAD vdd3o! pmos4 L=5.5e-07 W=6.6e-05 AD=1.3035e-10 AS=1.3365e-10 PD=6.995e-05 PS=4.05e-06 NRD=0.00643939 NRS=0.00643939 $X=46875 $Y=181100 $D=41
M39 PAD 11 vdd3o! vdd3o! pmos4 L=5.5e-07 W=6.6e-05 AD=1.3365e-10 AS=1.3035e-10 PD=4.05e-06 PS=6.995e-05 NRD=0.00643939 NRS=0.00643939 $X=52575 $Y=181100 $D=41
M40 vdd3o! 11 PAD vdd3o! pmos4 L=5.5e-07 W=6.6e-05 AD=1.3035e-10 AS=1.3365e-10 PD=6.995e-05 PS=4.05e-06 NRD=0.00643939 NRS=0.00643939 $X=57175 $Y=181100 $D=41
M41 PAD 11 vdd3o! vdd3o! pmos4 L=5.5e-07 W=6.6e-05 AD=1.3365e-10 AS=1.3035e-10 PD=4.05e-06 PS=6.995e-05 NRD=0.00643939 NRS=0.00643939 $X=62875 $Y=181100 $D=41
M42 vdd3o! 11 PAD vdd3o! pmos4 L=5.5e-07 W=6.6e-05 AD=1.3035e-10 AS=1.3365e-10 PD=6.995e-05 PS=4.05e-06 NRD=0.00643939 NRS=0.00643939 $X=67475 $Y=181100 $D=41
M43 PAD 11 vdd3o! vdd3o! pmos4 L=5.5e-07 W=6.6e-05 AD=1.3365e-10 AS=1.3035e-10 PD=4.05e-06 PS=6.995e-05 NRD=0.00643939 NRS=0.00643939 $X=73175 $Y=181100 $D=41
M44 vdd3r1! 9 Y vdd3r1! pmos4 L=3.5e-07 W=6.5e-06 AD=4.3875e-12 AS=7.6375e-12 PD=1.35e-06 PS=8.85e-06 NRD=0.0653846 NRS=0.0653846 $X=73175 $Y=320600 $D=41
M45 Y 9 vdd3r1! vdd3r1! pmos4 L=3.5e-07 W=6.5e-06 AD=4.3875e-12 AS=4.3875e-12 PD=1.35e-06 PS=1.35e-06 NRD=0.0653846 NRS=0.0653846 $X=74875 $Y=320600 $D=41
M46 vdd3r1! 9 Y vdd3r1! pmos4 L=3.5e-07 W=6.5e-06 AD=4.3875e-12 AS=4.3875e-12 PD=1.35e-06 PS=1.35e-06 NRD=0.0653846 NRS=0.0653846 $X=76575 $Y=320600 $D=41
M47 vdd3o! 11 PAD vdd3o! pmos4 L=5.5e-07 W=6.6e-05 AD=1.3035e-10 AS=1.3365e-10 PD=6.995e-05 PS=4.05e-06 NRD=0.00643939 NRS=0.00643939 $X=77775 $Y=181100 $D=41
M48 Y 9 vdd3r1! vdd3r1! pmos4 L=3.5e-07 W=6.5e-06 AD=7.6375e-12 AS=4.3875e-12 PD=8.85e-06 PS=1.35e-06 NRD=0.0653846 NRS=0.0653846 $X=78275 $Y=320600 $D=41
M49 vdd3r1! 10 9 vdd3r1! pmos4 L=3.5e-07 W=6.7e-06 AD=7.8725e-12 AS=7.8725e-12 PD=9.05e-06 PS=9.05e-06 NRD=0.0634328 NRS=0.0634328 $X=81725 $Y=320600 $D=41
M50 PAD 11 vdd3o! vdd3o! pmos4 L=5.5e-07 W=6.6e-05 AD=1.3365e-10 AS=1.3035e-10 PD=4.05e-06 PS=6.995e-05 NRD=0.00643939 NRS=0.00643939 $X=83475 $Y=181100 $D=41
M51 vdd3o! 11 PAD vdd3o! pmos4 L=5.5e-07 W=6.6e-05 AD=1.2705e-10 AS=1.3365e-10 PD=6.985e-05 PS=4.05e-06 NRD=0.00643939 NRS=0.00643939 $X=88075 $Y=181100 $D=41
.ENDS
***************************************
.SUBCKT VDD3OP vdd3r2! gnd3r! vdd3r1! gnd3o! vdd3o!
** N=8 EP=5 IP=1 FDC=17
R0 7 gnd3o! L=0.000437614 W=4e-07 $[rpoly1] $X=14050 $Y=257200 $D=8
D1 gnd3o! gnd3r! pd AREA=51.625 PJ=148.9 $X=12000 $Y=279300 $D=64
D2 gnd3r! gnd3o! pd AREA=51.625 PJ=148.9 $X=12000 $Y=286700 $D=64
D3 gnd3r! vdd3r1! nwd AREA=1899.68 PJ=198.4 $X=0 $Y=314250 $D=65
D4 gnd3o! gnd3r! nwd AREA=335.06 PJ=161.1 $X=10800 $Y=278100 $D=65
D5 gnd3o! gnd3o! nwd AREA=335.06 PJ=161.1 $X=10800 $Y=285500 $D=65
D6 gnd3o! vdd3o! nwd AREA=1538.5 PJ=794.4 $X=24950 $Y=107550 $D=65
D7 gnd3o! vdd3o! nwd AREA=508.84 PJ=238.657 $X=39500 $Y=119350 $D=65
D8 gnd3o! vdd3o! nwd AREA=508.84 PJ=238.657 $X=56200 $Y=119350 $D=65
D9 gnd3o! vdd3o! nwd AREA=508.84 PJ=238.657 $X=72900 $Y=119350 $D=65
D10 gnd3r! vdd3r2! nwd AREA=1055.32 PJ=231.5 $X=0 $Y=256750 $D=65
M11 vdd3o! 7 gnd3o! gnd3o! nmos4 L=5.5e-07 W=0.0001201 AD=6.21517e-10 AS=2.13177e-10 PD=1.035e-05 PS=0.00012365 NRD=0.00353872 NRS=0.00353872 $X=35975 $Y=116350 $D=37
M12 gnd3o! 7 vdd3o! gnd3o! nmos4 L=5.5e-07 W=0.0001201 AD=2.01167e-10 AS=6.21517e-10 PD=0.00012345 PS=1.035e-05 NRD=0.00353872 NRS=0.00353872 $X=46875 $Y=116350 $D=37
M13 vdd3o! 7 gnd3o! gnd3o! nmos4 L=5.5e-07 W=0.0001201 AD=6.21517e-10 AS=2.01167e-10 PD=1.035e-05 PS=0.00012345 NRD=0.00353872 NRS=0.00353872 $X=52675 $Y=116350 $D=37
M14 gnd3o! 7 vdd3o! gnd3o! nmos4 L=5.5e-07 W=0.0001201 AD=2.01167e-10 AS=6.21517e-10 PD=0.00012345 PS=1.035e-05 NRD=0.00353872 NRS=0.00353872 $X=63575 $Y=116350 $D=37
M15 vdd3o! 7 gnd3o! gnd3o! nmos4 L=5.5e-07 W=0.0001201 AD=6.21517e-10 AS=2.01167e-10 PD=1.035e-05 PS=0.00012345 NRD=0.00353872 NRS=0.00353872 $X=69375 $Y=116350 $D=37
M16 gnd3o! 7 vdd3o! gnd3o! nmos4 L=5.5e-07 W=0.0001201 AD=2.13177e-10 AS=6.21517e-10 PD=0.00012365 PS=1.035e-05 NRD=0.00353872 NRS=0.00353872 $X=80275 $Y=116350 $D=37
*.CALIBRE WARNING SHORT Short circuit(s) detected by extraction in this cell. See extraction report for details.
.ENDS
***************************************
.SUBCKT VDD3RP vdd3r1! gnd3r! gnd3o! 5
** N=6 EP=4 IP=1 FDC=15
*.CALIBRE ISOLATED NETS: vdd3o!
R0 5 gnd3r! L=0.000438254 W=4e-07 $[rpoly1] $X=67400 $Y=257950 $D=8
D1 gnd3o! gnd3r! pd AREA=43.925 PJ=126.9 $X=32300 $Y=266100 $D=64
D2 gnd3r! gnd3o! pd AREA=43.925 PJ=126.9 $X=39700 $Y=266100 $D=64
D3 gnd3r! vdd3r1! nwd AREA=1538.5 PJ=794.4 $X=24950 $Y=107550 $D=65
D4 gnd3r! gnd3r! nwd AREA=286.66 PJ=139.1 $X=31100 $Y=264900 $D=65
D5 gnd3r! gnd3o! nwd AREA=286.66 PJ=139.1 $X=38500 $Y=264900 $D=65
D6 gnd3r! vdd3r1! nwd AREA=508.84 PJ=238.657 $X=39500 $Y=119350 $D=65
D7 gnd3r! vdd3r1! nwd AREA=508.84 PJ=238.657 $X=56200 $Y=119350 $D=65
D8 gnd3r! vdd3r1! nwd AREA=508.84 PJ=238.657 $X=72900 $Y=119350 $D=65
M9 vdd3r1! 5 gnd3r! gnd3r! nmos4 L=5.5e-07 W=0.0001201 AD=6.21517e-10 AS=2.13177e-10 PD=1.035e-05 PS=0.00012365 NRD=0.00353872 NRS=0.00353872 $X=35975 $Y=116350 $D=37
M10 gnd3r! 5 vdd3r1! gnd3r! nmos4 L=5.5e-07 W=0.0001201 AD=2.01167e-10 AS=6.21517e-10 PD=0.00012345 PS=1.035e-05 NRD=0.00353872 NRS=0.00353872 $X=46875 $Y=116350 $D=37
M11 vdd3r1! 5 gnd3r! gnd3r! nmos4 L=5.5e-07 W=0.0001201 AD=6.21517e-10 AS=2.01167e-10 PD=1.035e-05 PS=0.00012345 NRD=0.00353872 NRS=0.00353872 $X=52675 $Y=116350 $D=37
M12 gnd3r! 5 vdd3r1! gnd3r! nmos4 L=5.5e-07 W=0.0001201 AD=2.01167e-10 AS=6.21517e-10 PD=0.00012345 PS=1.035e-05 NRD=0.00353872 NRS=0.00353872 $X=63575 $Y=116350 $D=37
M13 vdd3r1! 5 gnd3r! gnd3r! nmos4 L=5.5e-07 W=0.0001201 AD=6.21517e-10 AS=2.01167e-10 PD=1.035e-05 PS=0.00012345 NRD=0.00353872 NRS=0.00353872 $X=69375 $Y=116350 $D=37
M14 gnd3r! 5 vdd3r1! gnd3r! nmos4 L=5.5e-07 W=0.0001201 AD=2.13177e-10 AS=6.21517e-10 PD=0.00012365 PS=1.035e-05 NRD=0.00353872 NRS=0.00353872 $X=80275 $Y=116350 $D=37
*.CALIBRE WARNING SHORT Short circuit(s) detected by extraction in this cell. See extraction report for details.
.ENDS
***************************************
.SUBCKT VDD3IP gnd3r! vdd3r1! gnd3o! A
** N=8 EP=4 IP=1 FDC=16
*.CALIBRE ISOLATED NETS: vdd3r2! vdd3o!
R0 gnd3o! 8 L=0.000437491 W=4e-07 $[rpoly1] $X=6200 $Y=297750 $D=8
D1 gnd3o! A pd AREA=46.655 PJ=134.7 $X=82100 $Y=104500 $D=64
D2 gnd3o! A pd AREA=46.655 PJ=134.7 $X=84700 $Y=104500 $D=64
D3 gnd3o! A pd AREA=46.655 PJ=134.7 $X=87300 $Y=104500 $D=64
D4 gnd3r! vdd3r1! nwd AREA=1884.36 PJ=196.8 $X=800 $Y=314250 $D=65
D5 gnd3o! A nwd AREA=1250.68 PJ=654 $X=15800 $Y=182750 $D=65
D6 gnd3o! A nwd AREA=354.4 PJ=168.457 $X=30350 $Y=194550 $D=65
D7 gnd3o! A nwd AREA=354.4 PJ=168.457 $X=47050 $Y=194550 $D=65
D8 gnd3o! A nwd AREA=354.4 PJ=168.457 $X=63750 $Y=194550 $D=65
D9 gnd3o! A nwd AREA=699.435 PJ=161.1 $X=80100 $Y=102500 $D=65
M10 A 8 gnd3o! gnd3o! nmos4 L=5.5e-07 W=8.5e-05 AD=4.39875e-10 AS=1.50875e-10 PD=1.035e-05 PS=8.855e-05 NRD=0.005 NRS=0.005 $X=26825 $Y=191550 $D=37
M11 gnd3o! 8 A gnd3o! nmos4 L=5.5e-07 W=8.5e-05 AD=1.42375e-10 AS=4.39875e-10 PD=8.835e-05 PS=1.035e-05 NRD=0.005 NRS=0.005 $X=37725 $Y=191550 $D=37
M12 A 8 gnd3o! gnd3o! nmos4 L=5.5e-07 W=8.5e-05 AD=4.39875e-10 AS=1.42375e-10 PD=1.035e-05 PS=8.835e-05 NRD=0.005 NRS=0.005 $X=43525 $Y=191550 $D=37
M13 gnd3o! 8 A gnd3o! nmos4 L=5.5e-07 W=8.5e-05 AD=1.42375e-10 AS=4.39875e-10 PD=8.835e-05 PS=1.035e-05 NRD=0.005 NRS=0.005 $X=54425 $Y=191550 $D=37
M14 A 8 gnd3o! gnd3o! nmos4 L=5.5e-07 W=8.5e-05 AD=4.39875e-10 AS=1.42375e-10 PD=1.035e-05 PS=8.835e-05 NRD=0.005 NRS=0.005 $X=60225 $Y=191550 $D=37
M15 gnd3o! 8 A gnd3o! nmos4 L=5.5e-07 W=8.5e-05 AD=1.50875e-10 AS=4.39875e-10 PD=8.855e-05 PS=1.035e-05 NRD=0.005 NRS=0.005 $X=71125 $Y=191550 $D=37
.ENDS
***************************************
.SUBCKT GND3RP vdd3r! gnd3r! gnd3o! 5
** N=6 EP=4 IP=1 FDC=15
*.CALIBRE ISOLATED NETS: vdd3o!
R0 5 gnd3r! L=0.000437922 W=4e-07 $[rpoly1] $X=36700 $Y=254800 $D=8
D1 gnd3o! gnd3r! pd AREA=43.925 PJ=126.9 $X=52200 $Y=266100 $D=64
D2 gnd3r! gnd3o! pd AREA=43.925 PJ=126.9 $X=59600 $Y=266100 $D=64
D3 gnd3r! vdd3r! nwd AREA=1357.28 PJ=798.4 $X=24950 $Y=107550 $D=65
D4 gnd3r! vdd3r! nwd AREA=516.32 PJ=242.057 $X=39500 $Y=119350 $D=65
D5 gnd3r! gnd3r! nwd AREA=286.66 PJ=139.1 $X=51000 $Y=264900 $D=65
D6 gnd3r! gnd3o! nwd AREA=286.66 PJ=139.1 $X=58400 $Y=264900 $D=65
D7 gnd3r! vdd3r! nwd AREA=516.32 PJ=242.057 $X=56200 $Y=119350 $D=65
D8 gnd3r! vdd3r! nwd AREA=516.32 PJ=242.057 $X=72900 $Y=119350 $D=65
M9 vdd3r! 5 gnd3r! gnd3r! nmos4 L=5.5e-07 W=0.0001218 AD=6.30315e-10 AS=2.16195e-10 PD=1.035e-05 PS=0.00012535 NRD=0.00348933 NRS=0.00348933 $X=35975 $Y=116350 $D=37
M10 gnd3r! 5 vdd3r! gnd3r! nmos4 L=5.5e-07 W=0.0001218 AD=2.04015e-10 AS=6.30315e-10 PD=0.00012515 PS=1.035e-05 NRD=0.00348933 NRS=0.00348933 $X=46875 $Y=116350 $D=37
M11 vdd3r! 5 gnd3r! gnd3r! nmos4 L=5.5e-07 W=0.0001218 AD=6.30315e-10 AS=2.04015e-10 PD=1.035e-05 PS=0.00012515 NRD=0.00348933 NRS=0.00348933 $X=52675 $Y=116350 $D=37
M12 gnd3r! 5 vdd3r! gnd3r! nmos4 L=5.5e-07 W=0.0001218 AD=2.04015e-10 AS=6.30315e-10 PD=0.00012515 PS=1.035e-05 NRD=0.00348933 NRS=0.00348933 $X=63575 $Y=116350 $D=37
M13 vdd3r! 5 gnd3r! gnd3r! nmos4 L=5.5e-07 W=0.0001218 AD=6.30315e-10 AS=2.04015e-10 PD=1.035e-05 PS=0.00012515 NRD=0.00348933 NRS=0.00348933 $X=69375 $Y=116350 $D=37
M14 gnd3r! 5 vdd3r! gnd3r! nmos4 L=5.5e-07 W=0.0001218 AD=2.16195e-10 AS=6.30315e-10 PD=0.00012535 PS=1.035e-05 NRD=0.00348933 NRS=0.00348933 $X=80275 $Y=116350 $D=37
*.CALIBRE WARNING SHORT Short circuit(s) detected by extraction in this cell. See extraction report for details.
.ENDS
***************************************
.SUBCKT GND3OP gnd3r! gnd3o! vdd3o! 7
** N=8 EP=4 IP=1 FDC=15
*.CALIBRE ISOLATED NETS: vdd3r2! vdd3r1!
R0 gnd3o! 7 L=0.000437568 W=4e-07 $[rpoly1] $X=16450 $Y=144400 $D=8
D1 gnd3r! gnd3o! pd AREA=48.72 PJ=140.6 $X=45300 $Y=257000 $D=64
D2 gnd3o! gnd3r! pd AREA=48.72 PJ=140.6 $X=52700 $Y=257000 $D=64
D3 gnd3o! vdd3o! nwd AREA=1357.28 PJ=798.4 $X=24950 $Y=107550 $D=65
D4 gnd3o! vdd3o! nwd AREA=516.32 PJ=242.057 $X=39500 $Y=119350 $D=65
D5 gnd3o! gnd3o! nwd AREA=316.8 PJ=152.8 $X=44100 $Y=255800 $D=65
D6 gnd3o! gnd3r! nwd AREA=316.8 PJ=152.8 $X=51500 $Y=255800 $D=65
D7 gnd3o! vdd3o! nwd AREA=516.32 PJ=242.057 $X=56200 $Y=119350 $D=65
D8 gnd3o! vdd3o! nwd AREA=516.32 PJ=242.057 $X=72900 $Y=119350 $D=65
M9 vdd3o! 7 gnd3o! gnd3o! nmos4 L=5.5e-07 W=0.0001218 AD=6.30315e-10 AS=2.16195e-10 PD=1.035e-05 PS=0.00012535 NRD=0.00348933 NRS=0.00348933 $X=35975 $Y=116350 $D=37
M10 gnd3o! 7 vdd3o! gnd3o! nmos4 L=5.5e-07 W=0.0001218 AD=2.04015e-10 AS=6.30315e-10 PD=0.00012515 PS=1.035e-05 NRD=0.00348933 NRS=0.00348933 $X=46875 $Y=116350 $D=37
M11 vdd3o! 7 gnd3o! gnd3o! nmos4 L=5.5e-07 W=0.0001218 AD=6.30315e-10 AS=2.04015e-10 PD=1.035e-05 PS=0.00012515 NRD=0.00348933 NRS=0.00348933 $X=52675 $Y=116350 $D=37
M12 gnd3o! 7 vdd3o! gnd3o! nmos4 L=5.5e-07 W=0.0001218 AD=2.04015e-10 AS=6.30315e-10 PD=0.00012515 PS=1.035e-05 NRD=0.00348933 NRS=0.00348933 $X=63575 $Y=116350 $D=37
M13 vdd3o! 7 gnd3o! gnd3o! nmos4 L=5.5e-07 W=0.0001218 AD=6.30315e-10 AS=2.04015e-10 PD=1.035e-05 PS=0.00012515 NRD=0.00348933 NRS=0.00348933 $X=69375 $Y=116350 $D=37
M14 gnd3o! 7 vdd3o! gnd3o! nmos4 L=5.5e-07 W=0.0001218 AD=2.16195e-10 AS=6.30315e-10 PD=0.00012535 PS=1.035e-05 NRD=0.00348933 NRS=0.00348933 $X=80275 $Y=116350 $D=37
*.CALIBRE WARNING SHORT Short circuit(s) detected by extraction in this cell. See extraction report for details.
.ENDS
***************************************
.SUBCKT GND3IP gnd3o! A
** N=8 EP=2 IP=1 FDC=8
*.CALIBRE ISOLATED NETS: vdd3r2! gnd3r! vdd3r1! vdd3o!
D0 gnd3o! A pd AREA=87.01 PJ=250 $X=35400 $Y=196850 $D=64
D1 gnd3o! A pd AREA=87.01 PJ=250 $X=45300 $Y=109850 $D=64
D2 A gnd3o! pd AREA=87.01 PJ=250 $X=52700 $Y=109850 $D=64
D3 A gnd3o! pd AREA=87.01 PJ=250 $X=62600 $Y=196850 $D=64
D4 gnd3o! A nwd AREA=557.48 PJ=262.2 $X=34200 $Y=195650 $D=65
D5 gnd3o! A nwd AREA=557.48 PJ=262.2 $X=44100 $Y=108650 $D=65
D6 gnd3o! gnd3o! nwd AREA=557.48 PJ=262.2 $X=51500 $Y=108650 $D=65
D7 gnd3o! gnd3o! nwd AREA=557.48 PJ=262.2 $X=61400 $Y=195650 $D=65
.ENDS
***************************************
.SUBCKT CORNERP
** N=6 EP=0 IP=0 FDC=0
*.CALIBRE ISOLATED NETS: gnd3o! vdd3o! vdd3r2! gnd3r! vdd3r1!
.ENDS
***************************************
.SUBCKT PERI_SPACER_50_P
** N=5 EP=0 IP=0 FDC=0
.ENDS
***************************************
.SUBCKT PERI_SPACER_100_P
** N=5 EP=0 IP=0 FDC=0
.ENDS
***************************************
.SUBCKT PWRCUT_DIG_P_DX vddr_left! gndo_left! gndr_left! gndr_right! gndo_right! vddr_right!
** N=11 EP=6 IP=0 FDC=30
*.CALIBRE ISOLATED NETS: vddo_left! vddo_right!
D0 gndo_right! gndo_left! pd AREA=26.55 PJ=60.8 $X=10250 $Y=121450 $D=64
D1 gndo_right! gndo_left! pd AREA=26.55 PJ=60.8 $X=10250 $Y=124250 $D=64
D2 gndo_right! gndo_left! pd AREA=26.55 PJ=60.8 $X=10250 $Y=127050 $D=64
D3 gndo_right! gndo_left! pd AREA=26.55 PJ=60.8 $X=10250 $Y=129850 $D=64
D4 gndo_right! gndo_left! pd AREA=26.55 PJ=60.8 $X=10250 $Y=132650 $D=64
D5 gndo_right! gndo_left! pd AREA=26.55 PJ=60.8 $X=10250 $Y=135450 $D=64
D6 gndo_right! gndo_left! pd AREA=26.55 PJ=60.8 $X=10250 $Y=138250 $D=64
D7 gndo_right! gndo_left! pd AREA=26.55 PJ=60.8 $X=10250 $Y=141050 $D=64
D8 gndo_left! gndo_right! pd AREA=26.55 PJ=60.8 $X=10250 $Y=149550 $D=64
D9 gndo_left! gndo_right! pd AREA=26.55 PJ=60.8 $X=10250 $Y=152350 $D=64
D10 gndo_left! gndo_right! pd AREA=26.55 PJ=60.8 $X=10250 $Y=155150 $D=64
D11 gndo_left! gndo_right! pd AREA=26.55 PJ=60.8 $X=10250 $Y=157950 $D=64
D12 gndo_left! gndo_right! pd AREA=26.55 PJ=60.8 $X=10250 $Y=160750 $D=64
D13 gndo_left! gndo_right! pd AREA=26.55 PJ=60.8 $X=10250 $Y=163550 $D=64
D14 gndo_left! gndo_right! pd AREA=26.55 PJ=60.8 $X=10250 $Y=166350 $D=64
D15 gndo_left! gndo_right! pd AREA=26.55 PJ=60.8 $X=10250 $Y=169150 $D=64
D16 gndr_right! gndr_left! pd AREA=38.16 PJ=86.6 $X=12700 $Y=260950 $D=64
D17 gndr_right! gndr_left! pd AREA=38.16 PJ=86.6 $X=15500 $Y=260950 $D=64
D18 gndr_right! gndr_left! pd AREA=38.16 PJ=86.6 $X=18300 $Y=260950 $D=64
D19 gndr_left! gndr_right! pd AREA=38.16 PJ=86.6 $X=26800 $Y=260950 $D=64
D20 gndr_left! gndr_right! pd AREA=38.16 PJ=86.6 $X=29600 $Y=260950 $D=64
D21 gndr_left! gndr_right! pd AREA=38.16 PJ=86.6 $X=32400 $Y=260950 $D=64
D22 gndr_left! vddr_left! nwd AREA=72.45 PJ=30.15 $X=0 $Y=256750 $D=65
D23 gndr_left! vddr_left! nwd AREA=57.45 PJ=25.15 $X=0 $Y=314250 $D=65
D24 gndo_left! gndo_left! nwd AREA=855.91 PJ=118.4 $X=7950 $Y=119150 $D=65
D25 gndo_right! gndo_right! nwd AREA=855.91 PJ=118.4 $X=7950 $Y=147250 $D=65
D26 gndr_left! gndr_left! nwd AREA=521.7 PJ=116.2 $X=10400 $Y=258650 $D=65
D27 gndr_right! gndr_right! nwd AREA=521.7 PJ=116.2 $X=24500 $Y=258650 $D=65
D28 gndr_right! vddr_right! nwd AREA=70.035 PJ=29.95 $X=47000 $Y=256750 $D=65
D29 gndr_right! vddr_right! nwd AREA=57.45 PJ=25.15 $X=47000 $Y=314250 $D=65
.ENDS
***************************************
.SUBCKT V500_20 VDD GND
** N=2 EP=2 IP=0 FDC=1
C0 GND VDD $[cpolya] $A=9800 $P=1020 $X=2150 $Y=3100 $D=58
.ENDS
***************************************
.SUBCKT nmos4_CDNS_7807366010344 1 2 3 4
** N=4 EP=4 IP=0 FDC=2
M0 2 3 1 4 nmos4 L=3.5e-07 W=1e-05 AD=5e-12 AS=8.5e-12 PD=1e-06 PS=1.17e-05 NRD=0.0425 NRS=0.0425 $X=0 $Y=850 $D=37
M1 1 3 2 4 nmos4 L=3.5e-07 W=1e-05 AD=8.5e-12 AS=5e-12 PD=1.17e-05 PS=1e-06 NRD=0.0425 NRS=0.0425 $X=0 $Y=2200 $D=37
.ENDS
***************************************
.SUBCKT pmos4_CDNS_7807366010345 1 2 3 5
** N=5 EP=4 IP=0 FDC=4
M0 2 3 1 5 pmos4 L=3.5e-07 W=1e-05 AD=5e-12 AS=8.5e-12 PD=1e-06 PS=1.17e-05 NRD=0.0425 NRS=0.0425 $X=0 $Y=850 $D=41
M1 1 3 2 5 pmos4 L=3.5e-07 W=1e-05 AD=5e-12 AS=5e-12 PD=1e-06 PS=1e-06 NRD=0.0425 NRS=0.0425 $X=0 $Y=2200 $D=41
M2 2 3 1 5 pmos4 L=3.5e-07 W=1e-05 AD=5e-12 AS=5e-12 PD=1e-06 PS=1e-06 NRD=0.0425 NRS=0.0425 $X=0 $Y=3550 $D=41
M3 1 3 2 5 pmos4 L=3.5e-07 W=1e-05 AD=8.5e-12 AS=5e-12 PD=1.17e-05 PS=1e-06 NRD=0.0425 NRS=0.0425 $X=0 $Y=4900 $D=41
.ENDS
***************************************
.SUBCKT ND_C_CDNS_78073660103269
** N=2 EP=0 IP=0 FDC=0
.ENDS
***************************************
.SUBCKT chopper2 inn inp outn outp clk clkn VDDA GNDA
** N=8 EP=8 IP=42 FDC=25
D0 GNDA VDDA p_nwd AREA=518.32 PJ=108.4 $X=42300 $Y=24300 $D=87
X1 inp outp clk GNDA nmos4_CDNS_7807366010344 $T=9900 35500 0 270 $X=9650 $Y=24950
X2 inp outn clkn GNDA nmos4_CDNS_7807366010344 $T=18300 35500 0 270 $X=18050 $Y=24950
X3 inn outp clkn GNDA nmos4_CDNS_7807366010344 $T=26700 35500 0 270 $X=26450 $Y=24950
X4 inn outn clk GNDA nmos4_CDNS_7807366010344 $T=35100 35500 0 270 $X=34850 $Y=24950
X5 outn inn clkn VDDA pmos4_CDNS_7807366010345 $T=43500 35500 0 270 $X=42300 $Y=24300
X6 outp inn clk VDDA pmos4_CDNS_7807366010345 $T=54600 35500 0 270 $X=53400 $Y=24300
X7 outp inp clkn VDDA pmos4_CDNS_7807366010345 $T=65700 35500 0 270 $X=64500 $Y=24300
X8 outn inp clk VDDA pmos4_CDNS_7807366010345 $T=76800 35500 0 270 $X=75600 $Y=24300
.ENDS
***************************************
.SUBCKT ND_C_CDNS_78073660103261
** N=2 EP=0 IP=0 FDC=0
.ENDS
***************************************
.SUBCKT pmos4_CDNS_7807366010349 1 2 3
** N=4 EP=3 IP=0 FDC=1
M0 2 3 1 1 pmos4 L=3.5e-07 W=1.4e-06 AD=1.19e-12 AS=1.19e-12 PD=3.1e-06 PS=3.1e-06 NRD=0.303571 NRS=0.303571 $X=0 $Y=850 $D=41
.ENDS
***************************************
.SUBCKT nmos4_CDNS_7807366010348 1 2 3
** N=3 EP=3 IP=0 FDC=1
M0 2 3 1 1 nmos4 L=3.5e-07 W=8e-07 AD=6.8e-13 AS=6.8e-13 PD=2.5e-06 PS=2.5e-06 NRD=0.53125 NRS=0.53125 $X=0 $Y=850 $D=37
.ENDS
***************************************
.SUBCKT rpolyhc_CDNS_7807366010356 1 2
** N=3 EP=2 IP=0 FDC=1
R0 1 2 L=1.5e-05 W=2e-06 $[rpolyh] $X=600 $Y=0 $D=18
.ENDS
***************************************
.SUBCKT nmos4_CDNS_7807366010340 1 2 3 4
** N=4 EP=4 IP=0 FDC=2
M0 2 3 1 4 nmos4 L=4e-06 W=1e-05 AD=5e-12 AS=8.5e-12 PD=1e-06 PS=1.17e-05 NRD=0.0425 NRS=0.0425 $X=0 $Y=850 $D=37
M1 1 3 2 4 nmos4 L=4e-06 W=1e-05 AD=8.5e-12 AS=5e-12 PD=1.17e-05 PS=1e-06 NRD=0.0425 NRS=0.0425 $X=0 $Y=5850 $D=37
.ENDS
***************************************
.SUBCKT ND_C_CDNS_78073660103241
** N=2 EP=0 IP=0 FDC=0
.ENDS
***************************************
.SUBCKT pmos4_CDNS_7807366010352 1 2 3
** N=4 EP=3 IP=0 FDC=6
M0 2 3 1 1 pmos4 L=4e-06 W=3.335e-05 AD=1.6675e-11 AS=2.83475e-11 PD=1e-06 PS=3.505e-05 NRD=0.0127436 NRS=0.0127436 $X=0 $Y=850 $D=41
M1 1 3 2 1 pmos4 L=4e-06 W=3.335e-05 AD=1.6675e-11 AS=1.6675e-11 PD=1e-06 PS=1e-06 NRD=0.0127436 NRS=0.0127436 $X=0 $Y=5850 $D=41
M2 2 3 1 1 pmos4 L=4e-06 W=3.335e-05 AD=1.6675e-11 AS=1.6675e-11 PD=1e-06 PS=1e-06 NRD=0.0127436 NRS=0.0127436 $X=0 $Y=10850 $D=41
M3 1 3 2 1 pmos4 L=4e-06 W=3.335e-05 AD=1.6675e-11 AS=1.6675e-11 PD=1e-06 PS=1e-06 NRD=0.0127436 NRS=0.0127436 $X=0 $Y=15850 $D=41
M4 2 3 1 1 pmos4 L=4e-06 W=3.335e-05 AD=1.6675e-11 AS=1.6675e-11 PD=1e-06 PS=1e-06 NRD=0.0127436 NRS=0.0127436 $X=0 $Y=20850 $D=41
M5 1 3 2 1 pmos4 L=4e-06 W=3.335e-05 AD=2.83475e-11 AS=1.6675e-11 PD=3.505e-05 PS=1e-06 NRD=0.0127436 NRS=0.0127436 $X=0 $Y=25850 $D=41
.ENDS
***************************************
.SUBCKT nmos4_CDNS_7807366010339
** N=4 EP=0 IP=0 FDC=0
.ENDS
***************************************
.SUBCKT ICV_117 3 4 5
** N=5 EP=3 IP=8 FDC=1
M0 4 5 3 3 nmos4 L=4e-05 W=2e-06 AD=1.7e-12 AS=1.7e-12 PD=3.7e-06 PS=3.7e-06 NRD=0.2125 NRS=0.2125 $X=3250 $Y=850 $D=37
.ENDS
***************************************
.SUBCKT ICV_118 3 4 5 6 7
** N=7 EP=5 IP=10 FDC=3
M0 5 7 3 3 nmos4 L=4e-05 W=2e-06 AD=1.7e-12 AS=1.7e-12 PD=3.7e-06 PS=3.7e-06 NRD=0.2125 NRS=0.2125 $X=6500 $Y=850 $D=37
X1 3 4 7 ICV_117 $T=0 0 0 0 $X=-400 $Y=-250
X2 3 6 7 ICV_117 $T=6500 0 0 0 $X=6100 $Y=-250
.ENDS
***************************************
.SUBCKT pmos4_CDNS_7807366010355
** N=4 EP=0 IP=0 FDC=0
.ENDS
***************************************
.SUBCKT ICV_116
** N=6 EP=0 IP=8 FDC=0
.ENDS
***************************************
.SUBCKT P1_C_CDNS_78073660103234
** N=2 EP=0 IP=0 FDC=0
.ENDS
***************************************
.SUBCKT pmos4_CDNS_7807366010338 1 2 3 5
** N=5 EP=4 IP=0 FDC=10
M0 2 3 1 5 pmos4 L=4e-06 W=1e-05 AD=5e-12 AS=8.5e-12 PD=1e-06 PS=1.17e-05 NRD=0.0425 NRS=0.0425 $X=0 $Y=850 $D=41
M1 1 3 2 5 pmos4 L=4e-06 W=1e-05 AD=5e-12 AS=5e-12 PD=1e-06 PS=1e-06 NRD=0.0425 NRS=0.0425 $X=0 $Y=5850 $D=41
M2 2 3 1 5 pmos4 L=4e-06 W=1e-05 AD=5e-12 AS=5e-12 PD=1e-06 PS=1e-06 NRD=0.0425 NRS=0.0425 $X=0 $Y=10850 $D=41
M3 1 3 2 5 pmos4 L=4e-06 W=1e-05 AD=5e-12 AS=5e-12 PD=1e-06 PS=1e-06 NRD=0.0425 NRS=0.0425 $X=0 $Y=15850 $D=41
M4 2 3 1 5 pmos4 L=4e-06 W=1e-05 AD=5e-12 AS=5e-12 PD=1e-06 PS=1e-06 NRD=0.0425 NRS=0.0425 $X=0 $Y=20850 $D=41
M5 1 3 2 5 pmos4 L=4e-06 W=1e-05 AD=5e-12 AS=5e-12 PD=1e-06 PS=1e-06 NRD=0.0425 NRS=0.0425 $X=0 $Y=25850 $D=41
M6 2 3 1 5 pmos4 L=4e-06 W=1e-05 AD=5e-12 AS=5e-12 PD=1e-06 PS=1e-06 NRD=0.0425 NRS=0.0425 $X=0 $Y=30850 $D=41
M7 1 3 2 5 pmos4 L=4e-06 W=1e-05 AD=5e-12 AS=5e-12 PD=1e-06 PS=1e-06 NRD=0.0425 NRS=0.0425 $X=0 $Y=35850 $D=41
M8 2 3 1 5 pmos4 L=4e-06 W=1e-05 AD=5e-12 AS=5e-12 PD=1e-06 PS=1e-06 NRD=0.0425 NRS=0.0425 $X=0 $Y=40850 $D=41
M9 1 3 2 5 pmos4 L=4e-06 W=1e-05 AD=8.5e-12 AS=5e-12 PD=1.17e-05 PS=1e-06 NRD=0.0425 NRS=0.0425 $X=0 $Y=45850 $D=41
.ENDS
***************************************
.SUBCKT ND_C_CDNS_78073660103240
** N=2 EP=0 IP=0 FDC=0
.ENDS
***************************************
.SUBCKT P1_C_CDNS_78073660103233
** N=2 EP=0 IP=0 FDC=0
.ENDS
***************************************
.SUBCKT P1_C_CDNS_78073660103160
** N=2 EP=0 IP=0 FDC=0
.ENDS
***************************************
.SUBCKT nmos4_CDNS_7807366010350
** N=4 EP=0 IP=0 FDC=0
.ENDS
***************************************
.SUBCKT ICV_93
** N=6 EP=0 IP=8 FDC=0
.ENDS
***************************************
.SUBCKT ICV_94 3 4 5 6
** N=6 EP=4 IP=12 FDC=3
M0 4 6 3 3 nmos4 L=1.2e-05 W=4e-06 AD=3.4e-12 AS=3.4e-12 PD=5.7e-06 PS=5.7e-06 NRD=0.10625 NRS=0.10625 $X=5250 $Y=850 $D=37
M1 5 6 3 3 nmos4 L=1.2e-05 W=4e-06 AD=3.4e-12 AS=3.4e-12 PD=5.7e-06 PS=5.7e-06 NRD=0.10625 NRS=0.10625 $X=10500 $Y=850 $D=37
M2 4 6 3 3 nmos4 L=1.2e-05 W=4e-06 AD=3.4e-12 AS=3.4e-12 PD=5.7e-06 PS=5.7e-06 NRD=0.10625 NRS=0.10625 $X=15750 $Y=850 $D=37
.ENDS
***************************************
.SUBCKT nmos4_CDNS_7807366010343 1 2 3 4
** N=4 EP=4 IP=0 FDC=10
M0 2 3 1 4 nmos4 L=4e-06 W=1e-06 AD=5e-13 AS=8.5e-13 PD=1e-06 PS=2.7e-06 NRD=0.425 NRS=0.425 $X=0 $Y=850 $D=37
M1 1 3 2 4 nmos4 L=4e-06 W=1e-06 AD=5e-13 AS=5e-13 PD=1e-06 PS=1e-06 NRD=0.425 NRS=0.425 $X=0 $Y=5850 $D=37
M2 2 3 1 4 nmos4 L=4e-06 W=1e-06 AD=5e-13 AS=5e-13 PD=1e-06 PS=1e-06 NRD=0.425 NRS=0.425 $X=0 $Y=10850 $D=37
M3 1 3 2 4 nmos4 L=4e-06 W=1e-06 AD=5e-13 AS=5e-13 PD=1e-06 PS=1e-06 NRD=0.425 NRS=0.425 $X=0 $Y=15850 $D=37
M4 2 3 1 4 nmos4 L=4e-06 W=1e-06 AD=5e-13 AS=5e-13 PD=1e-06 PS=1e-06 NRD=0.425 NRS=0.425 $X=0 $Y=20850 $D=37
M5 1 3 2 4 nmos4 L=4e-06 W=1e-06 AD=5e-13 AS=5e-13 PD=1e-06 PS=1e-06 NRD=0.425 NRS=0.425 $X=0 $Y=25850 $D=37
M6 2 3 1 4 nmos4 L=4e-06 W=1e-06 AD=5e-13 AS=5e-13 PD=1e-06 PS=1e-06 NRD=0.425 NRS=0.425 $X=0 $Y=30850 $D=37
M7 1 3 2 4 nmos4 L=4e-06 W=1e-06 AD=5e-13 AS=5e-13 PD=1e-06 PS=1e-06 NRD=0.425 NRS=0.425 $X=0 $Y=35850 $D=37
M8 2 3 1 4 nmos4 L=4e-06 W=1e-06 AD=5e-13 AS=5e-13 PD=1e-06 PS=1e-06 NRD=0.425 NRS=0.425 $X=0 $Y=40850 $D=37
M9 1 3 2 4 nmos4 L=4e-06 W=1e-06 AD=8.5e-13 AS=5e-13 PD=2.7e-06 PS=1e-06 NRD=0.425 NRS=0.425 $X=0 $Y=45850 $D=37
.ENDS
***************************************
.SUBCKT pmos4_CDNS_7807366010354
** N=4 EP=0 IP=0 FDC=0
.ENDS
***************************************
.SUBCKT ICV_85
** N=6 EP=0 IP=8 FDC=0
.ENDS
***************************************
.SUBCKT ICV_86
** N=8 EP=0 IP=12 FDC=0
.ENDS
***************************************
.SUBCKT ICV_87 1
** N=9 EP=1 IP=16 FDC=1
M0 1 1 1 1 pmos4 L=1.2e-05 W=1e-05 AD=8.5e-12 AS=8.5e-12 PD=1.17e-05 PS=1.17e-05 NRD=0.0425 NRS=0.0425 $X=0 $Y=850 $D=42
.ENDS
***************************************
.SUBCKT P1_C_CDNS_78073660103237
** N=2 EP=0 IP=0 FDC=0
.ENDS
***************************************
.SUBCKT pmos4_CDNS_7807366010353
** N=4 EP=0 IP=0 FDC=0
.ENDS
***************************************
.SUBCKT ICV_109
** N=6 EP=0 IP=8 FDC=0
.ENDS
***************************************
.SUBCKT ICV_110 1 3 4 6 7
** N=8 EP=5 IP=12 FDC=3
M0 3 6 1 1 pmos4 L=4e-06 W=1.25e-05 AD=1.0625e-11 AS=1.0625e-11 PD=1.42e-05 PS=1.42e-05 NRD=0.034 NRS=0.034 $X=0 $Y=7150 $D=41
M1 4 7 1 1 pmos4 L=4e-06 W=1.25e-05 AD=1.0625e-11 AS=1.0625e-11 PD=1.42e-05 PS=1.42e-05 NRD=0.034 NRS=0.034 $X=0 $Y=13450 $D=41
M2 3 6 1 1 pmos4 L=4e-06 W=1.25e-05 AD=1.0625e-11 AS=1.0625e-11 PD=1.42e-05 PS=1.42e-05 NRD=0.034 NRS=0.034 $X=0 $Y=19750 $D=41
.ENDS
***************************************
.SUBCKT nmos4_CDNS_7807366010351
** N=3 EP=0 IP=0 FDC=0
.ENDS
***************************************
.SUBCKT ICV_115
** N=5 EP=0 IP=6 FDC=0
.ENDS
***************************************
.SUBCKT P1_C_CDNS_78073660103243
** N=1 EP=0 IP=0 FDC=0
.ENDS
***************************************
.SUBCKT rpolyhc_CDNS_7807366010358 1
** N=2 EP=1 IP=0 FDC=1
R0 1 1 L=5e-06 W=8e-07 $[rpolyh] $X=600 $Y=0 $D=18
.ENDS
***************************************
.SUBCKT cpolyc_CDNS_7807366010337 2 3
** N=3 EP=2 IP=0 FDC=1
C0 2 3 $[cpolya] $A=2560.2 $P=202.4 $X=1800 $Y=1000 $D=58
.ENDS
***************************************
.SUBCKT fecg_ia_5_fc 1 2 CLK EXC1 EXC2 VINN VINP 8 9 BIAS 11 VDDA 13 14 GNDA 16 17 18 19 20
+ VOUT 22 VREF GNDD VDDD
** N=41 EP=25 IP=657 FDC=376
R0 18 VOUT L=0.00239985 W=2e-06 $[rpolyh] $X=414000 $Y=47750 $D=18
D1 GNDD VDDD p_nwd AREA=49.9875 PJ=29.35 $X=58350 $Y=86050 $D=87
D2 GNDA GNDA p_nwd AREA=559.65 PJ=95.6 $X=109750 $Y=214050 $D=87
D3 GNDA 2 p_nwd AREA=1215.5 PJ=139.5 $X=166575 $Y=128475 $D=87
D4 GNDA 1 p_nwd AREA=1215.5 PJ=139.5 $X=166575 $Y=167975 $D=87
D5 GNDA 1 p_nwd AREA=1215.5 PJ=139.5 $X=204675 $Y=128475 $D=87
D6 GNDA 2 p_nwd AREA=1215.5 PJ=139.5 $X=204675 $Y=167975 $D=87
D7 GNDA VDDA p_nwd AREA=8337.85 PJ=426.8 $X=264925 $Y=191000 $D=87
D8 GNDA VDDA p_nwd AREA=3797.99 PJ=292.8 $X=284275 $Y=150600 $D=87
D9 GNDA GNDA p_nwd AREA=9730.07 PJ=641.1 $X=409200 $Y=43300 $D=87
D10 GNDA VDDA p_nwd AREA=28633.6 PJ=691.8 $X=462875 $Y=85450 $D=87
D11 GNDA 22 p_nwd AREA=4158.38 PJ=262.1 $X=708650 $Y=183900 $D=87
D12 GNDA GNDA p_nwd AREA=2974.36 PJ=237.95 $X=708850 $Y=64925 $D=87
D13 GNDA GNDA p_nwd AREA=28501.2 PJ=699.95 $X=804400 $Y=71025 $D=87
M14 39 39 39 GNDA nmos4 L=4e-05 W=2e-06 AD=1.7e-12 AS=1.7e-12 PD=3.7e-06 PS=3.7e-06 NRD=0.2125 NRS=0.2125 $X=208400 $Y=50475 $D=38
M15 39 39 39 GNDA nmos4 L=4e-05 W=2e-06 AD=1.7e-12 AS=1.7e-12 PD=3.7e-06 PS=3.7e-06 NRD=0.2125 NRS=0.2125 $X=286400 $Y=50475 $D=38
M16 30 30 30 GNDA nmos4 L=1.2e-05 W=4e-06 AD=3.4e-12 AS=3.4e-12 PD=5.7e-06 PS=5.7e-06 NRD=0.10625 NRS=0.10625 $X=321275 $Y=50250 $D=38
M17 29 29 29 GNDA nmos4 L=1.2e-05 W=4e-06 AD=3.4e-12 AS=3.4e-12 PD=5.7e-06 PS=5.7e-06 NRD=0.10625 NRS=0.10625 $X=321275 $Y=69950 $D=38
M18 30 30 30 GNDA nmos4 L=1.2e-05 W=4e-06 AD=3.4e-12 AS=3.4e-12 PD=5.7e-06 PS=5.7e-06 NRD=0.10625 NRS=0.10625 $X=368525 $Y=50250 $D=38
M19 29 29 29 GNDA nmos4 L=1.2e-05 W=4e-06 AD=3.4e-12 AS=3.4e-12 PD=5.7e-06 PS=5.7e-06 NRD=0.10625 NRS=0.10625 $X=368525 $Y=69950 $D=38
M20 GNDA GNDA GNDA GNDA nmos4 L=8e-06 W=1e-05 AD=8.5e-12 AS=8.5e-12 PD=1.17e-05 PS=1.17e-05 NRD=0.0425 NRS=0.0425 $X=719625 $Y=143050 $D=38
M21 GNDA GNDA GNDA GNDA nmos4 L=8e-06 W=1e-05 AD=8.5e-12 AS=8.5e-12 PD=1.17e-05 PS=1.17e-05 NRD=0.0425 NRS=0.0425 $X=719625 $Y=155750 $D=38
M22 GNDA GNDA GNDA GNDA nmos4 L=8e-06 W=1e-05 AD=8.5e-12 AS=8.5e-12 PD=1.17e-05 PS=1.17e-05 NRD=0.0425 NRS=0.0425 $X=771125 $Y=143050 $D=38
M23 GNDA GNDA GNDA GNDA nmos4 L=8e-06 W=1e-05 AD=8.5e-12 AS=8.5e-12 PD=1.17e-05 PS=1.17e-05 NRD=0.0425 NRS=0.0425 $X=771125 $Y=155750 $D=38
M24 20 BIAS 38 GNDA nmos4 L=4e-06 W=1e-05 AD=5e-12 AS=8.5e-12 PD=1e-06 PS=1.17e-05 NRD=0.0425 NRS=0.0425 $X=167275 $Y=59525 $D=37
M25 38 BIAS 20 GNDA nmos4 L=4e-06 W=1e-05 AD=5e-12 AS=5e-12 PD=1e-06 PS=1e-06 NRD=0.0425 NRS=0.0425 $X=172275 $Y=59525 $D=37
M26 20 BIAS 38 GNDA nmos4 L=4e-06 W=1e-05 AD=5e-12 AS=5e-12 PD=1e-06 PS=1e-06 NRD=0.0425 NRS=0.0425 $X=177275 $Y=59525 $D=37
M27 38 BIAS 20 GNDA nmos4 L=4e-06 W=1e-05 AD=8.5e-12 AS=5e-12 PD=1.17e-05 PS=1e-06 NRD=0.0425 NRS=0.0425 $X=182275 $Y=59525 $D=37
M28 29 39 GNDA GNDA nmos4 L=4e-05 W=2e-06 AD=1.7e-12 AS=1.7e-12 PD=3.7e-06 PS=3.7e-06 NRD=0.2125 NRS=0.2125 $X=221400 $Y=50475 $D=37
M29 29 39 GNDA GNDA nmos4 L=4e-05 W=2e-06 AD=1.7e-12 AS=1.7e-12 PD=3.7e-06 PS=3.7e-06 NRD=0.2125 NRS=0.2125 $X=234400 $Y=50475 $D=37
M30 39 39 GNDA GNDA nmos4 L=4e-05 W=2e-06 AD=1.7e-12 AS=1.7e-12 PD=3.7e-06 PS=3.7e-06 NRD=0.2125 NRS=0.2125 $X=247400 $Y=50475 $D=37
M31 29 39 GNDA GNDA nmos4 L=4e-05 W=2e-06 AD=1.7e-12 AS=1.7e-12 PD=3.7e-06 PS=3.7e-06 NRD=0.2125 NRS=0.2125 $X=260400 $Y=50475 $D=37
M32 29 39 GNDA GNDA nmos4 L=4e-05 W=2e-06 AD=1.7e-12 AS=1.7e-12 PD=3.7e-06 PS=3.7e-06 NRD=0.2125 NRS=0.2125 $X=273400 $Y=50475 $D=37
M33 GNDA 30 14 GNDA nmos4 L=1.2e-05 W=4e-06 AD=3.4e-12 AS=3.4e-12 PD=5.7e-06 PS=5.7e-06 NRD=0.10625 NRS=0.10625 $X=342275 $Y=50250 $D=37
M34 GNDA 29 19 GNDA nmos4 L=1.2e-05 W=4e-06 AD=3.4e-12 AS=3.4e-12 PD=5.7e-06 PS=5.7e-06 NRD=0.10625 NRS=0.10625 $X=342275 $Y=69950 $D=37
M35 GNDA 30 14 GNDA nmos4 L=1.2e-05 W=4e-06 AD=3.4e-12 AS=3.4e-12 PD=5.7e-06 PS=5.7e-06 NRD=0.10625 NRS=0.10625 $X=363275 $Y=50250 $D=37
M36 GNDA 29 19 GNDA nmos4 L=1.2e-05 W=4e-06 AD=3.4e-12 AS=3.4e-12 PD=5.7e-06 PS=5.7e-06 NRD=0.10625 NRS=0.10625 $X=363275 $Y=69950 $D=37
M37 VOUT 32 GNDA GNDA nmos4 L=2e-06 W=2.5e-06 AD=1.25e-12 AS=2.125e-12 PD=1e-06 PS=4.2e-06 NRD=0.17 NRS=0.17 $X=712725 $Y=51675 $D=37
M38 GNDA 32 VOUT GNDA nmos4 L=2e-06 W=2.5e-06 AD=1.25e-12 AS=1.25e-12 PD=1e-06 PS=1e-06 NRD=0.17 NRS=0.17 $X=715725 $Y=51675 $D=37
M39 VOUT 32 GNDA GNDA nmos4 L=2e-06 W=2.5e-06 AD=1.25e-12 AS=1.25e-12 PD=1e-06 PS=1e-06 NRD=0.17 NRS=0.17 $X=718725 $Y=51675 $D=37
M40 GNDA 32 VOUT GNDA nmos4 L=2e-06 W=2.5e-06 AD=2.125e-12 AS=1.25e-12 PD=4.2e-06 PS=1e-06 NRD=0.17 NRS=0.17 $X=721725 $Y=51675 $D=37
M41 33 33 GNDA GNDA nmos4 L=8e-06 W=1e-05 AD=8.5e-12 AS=8.5e-12 PD=1.17e-05 PS=1.17e-05 NRD=0.0425 NRS=0.0425 $X=729925 $Y=143050 $D=37
M42 32 33 GNDA GNDA nmos4 L=8e-06 W=1e-05 AD=8.5e-12 AS=8.5e-12 PD=1.17e-05 PS=1.17e-05 NRD=0.0425 NRS=0.0425 $X=729925 $Y=155750 $D=37
M43 32 33 GNDA GNDA nmos4 L=8e-06 W=1e-05 AD=8.5e-12 AS=8.5e-12 PD=1.17e-05 PS=1.17e-05 NRD=0.0425 NRS=0.0425 $X=740225 $Y=143050 $D=37
M44 33 33 GNDA GNDA nmos4 L=8e-06 W=1e-05 AD=8.5e-12 AS=8.5e-12 PD=1.17e-05 PS=1.17e-05 NRD=0.0425 NRS=0.0425 $X=740225 $Y=155750 $D=37
M45 32 33 GNDA GNDA nmos4 L=8e-06 W=1e-05 AD=8.5e-12 AS=8.5e-12 PD=1.17e-05 PS=1.17e-05 NRD=0.0425 NRS=0.0425 $X=750525 $Y=143050 $D=37
M46 33 33 GNDA GNDA nmos4 L=8e-06 W=1e-05 AD=8.5e-12 AS=8.5e-12 PD=1.17e-05 PS=1.17e-05 NRD=0.0425 NRS=0.0425 $X=750525 $Y=155750 $D=37
M47 33 33 GNDA GNDA nmos4 L=8e-06 W=1e-05 AD=8.5e-12 AS=8.5e-12 PD=1.17e-05 PS=1.17e-05 NRD=0.0425 NRS=0.0425 $X=760825 $Y=143050 $D=37
M48 32 33 GNDA GNDA nmos4 L=8e-06 W=1e-05 AD=8.5e-12 AS=8.5e-12 PD=1.17e-05 PS=1.17e-05 NRD=0.0425 NRS=0.0425 $X=760825 $Y=155750 $D=37
M49 VDDA VDDA VDDA VDDA pmos4 L=2e-05 W=1.25e-05 AD=1.0625e-11 AS=1.0625e-11 PD=1.42e-05 PS=1.42e-05 NRD=0.034 NRS=0.034 $X=280125 $Y=202350 $D=42
M50 VDDA VDDA VDDA VDDA pmos4 L=2e-05 W=1.25e-05 AD=1.0625e-11 AS=1.0625e-11 PD=1.42e-05 PS=1.42e-05 NRD=0.034 NRS=0.034 $X=280125 $Y=218650 $D=42
M51 VDDA VDDA VDDA VDDA pmos4 L=2e-05 W=1.25e-05 AD=1.0625e-11 AS=1.0625e-11 PD=1.42e-05 PS=1.42e-05 NRD=0.034 NRS=0.034 $X=391625 $Y=202350 $D=42
M52 VDDA VDDA VDDA VDDA pmos4 L=2e-05 W=1.25e-05 AD=1.0625e-11 AS=1.0625e-11 PD=1.42e-05 PS=1.42e-05 NRD=0.034 NRS=0.034 $X=391625 $Y=218650 $D=42
M53 VDDA VDDA VDDA VDDA pmos4 L=1.2e-05 W=1e-05 AD=8.5e-12 AS=8.5e-12 PD=1.17e-05 PS=1.17e-05 NRD=0.0425 NRS=0.0425 $X=482525 $Y=91050 $D=42
M54 VDDA VDDA VDDA VDDA pmos4 L=1.2e-05 W=1e-05 AD=8.5e-12 AS=8.5e-12 PD=1.17e-05 PS=1.17e-05 NRD=0.0425 NRS=0.0425 $X=482525 $Y=205750 $D=42
M55 VDDA VDDA VDDA VDDA pmos4 L=1.2e-05 W=1e-05 AD=8.5e-12 AS=8.5e-12 PD=1.17e-05 PS=1.17e-05 NRD=0.0425 NRS=0.0425 $X=496825 $Y=91050 $D=42
M56 VDDA VDDA VDDA VDDA pmos4 L=1.2e-05 W=1e-05 AD=8.5e-12 AS=8.5e-12 PD=1.17e-05 PS=1.17e-05 NRD=0.0425 NRS=0.0425 $X=496825 $Y=205750 $D=42
M57 VDDA VDDA VDDA VDDA pmos4 L=1.2e-05 W=1e-05 AD=8.5e-12 AS=8.5e-12 PD=1.17e-05 PS=1.17e-05 NRD=0.0425 NRS=0.0425 $X=511125 $Y=91050 $D=42
M58 VDDA VDDA VDDA VDDA pmos4 L=1.2e-05 W=1e-05 AD=8.5e-12 AS=8.5e-12 PD=1.17e-05 PS=1.17e-05 NRD=0.0425 NRS=0.0425 $X=511125 $Y=205750 $D=42
M59 VDDA VDDA VDDA VDDA pmos4 L=1.2e-05 W=1e-05 AD=8.5e-12 AS=8.5e-12 PD=1.17e-05 PS=1.17e-05 NRD=0.0425 NRS=0.0425 $X=525425 $Y=91050 $D=42
M60 VDDA VDDA VDDA VDDA pmos4 L=1.2e-05 W=1e-05 AD=8.5e-12 AS=8.5e-12 PD=1.17e-05 PS=1.17e-05 NRD=0.0425 NRS=0.0425 $X=525425 $Y=205750 $D=42
M61 VDDA VDDA VDDA VDDA pmos4 L=1.2e-05 W=1e-05 AD=8.5e-12 AS=8.5e-12 PD=1.17e-05 PS=1.17e-05 NRD=0.0425 NRS=0.0425 $X=539725 $Y=91050 $D=42
M62 VDDA VDDA VDDA VDDA pmos4 L=1.2e-05 W=1e-05 AD=8.5e-12 AS=8.5e-12 PD=1.17e-05 PS=1.17e-05 NRD=0.0425 NRS=0.0425 $X=539725 $Y=205750 $D=42
M63 VDDA VDDA VDDA VDDA pmos4 L=1.2e-05 W=1e-05 AD=8.5e-12 AS=8.5e-12 PD=1.17e-05 PS=1.17e-05 NRD=0.0425 NRS=0.0425 $X=554025 $Y=91050 $D=42
M64 VDDA VDDA VDDA VDDA pmos4 L=1.2e-05 W=1e-05 AD=8.5e-12 AS=8.5e-12 PD=1.17e-05 PS=1.17e-05 NRD=0.0425 NRS=0.0425 $X=554025 $Y=205750 $D=42
M65 VDDA VDDA VDDA VDDA pmos4 L=1.2e-05 W=1e-05 AD=8.5e-12 AS=8.5e-12 PD=1.17e-05 PS=1.17e-05 NRD=0.0425 NRS=0.0425 $X=568325 $Y=91050 $D=42
M66 VDDA VDDA VDDA VDDA pmos4 L=1.2e-05 W=1e-05 AD=8.5e-12 AS=8.5e-12 PD=1.17e-05 PS=1.17e-05 NRD=0.0425 NRS=0.0425 $X=568325 $Y=205750 $D=42
M67 VDDA VDDA VDDA VDDA pmos4 L=1.2e-05 W=1e-05 AD=8.5e-12 AS=8.5e-12 PD=1.17e-05 PS=1.17e-05 NRD=0.0425 NRS=0.0425 $X=582625 $Y=91050 $D=42
M68 VDDA VDDA VDDA VDDA pmos4 L=1.2e-05 W=1e-05 AD=8.5e-12 AS=8.5e-12 PD=1.17e-05 PS=1.17e-05 NRD=0.0425 NRS=0.0425 $X=582625 $Y=205750 $D=42
M69 VDDA VDDA VDDA VDDA pmos4 L=1.2e-05 W=1e-05 AD=8.5e-12 AS=8.5e-12 PD=1.17e-05 PS=1.17e-05 NRD=0.0425 NRS=0.0425 $X=596925 $Y=91050 $D=42
M70 VDDA VDDA VDDA VDDA pmos4 L=1.2e-05 W=1e-05 AD=8.5e-12 AS=8.5e-12 PD=1.17e-05 PS=1.17e-05 NRD=0.0425 NRS=0.0425 $X=596925 $Y=205750 $D=42
M71 VDDA VDDA VDDA VDDA pmos4 L=1.2e-05 W=1e-05 AD=8.5e-12 AS=8.5e-12 PD=1.17e-05 PS=1.17e-05 NRD=0.0425 NRS=0.0425 $X=611225 $Y=91050 $D=42
M72 VDDA VDDA VDDA VDDA pmos4 L=1.2e-05 W=1e-05 AD=8.5e-12 AS=8.5e-12 PD=1.17e-05 PS=1.17e-05 NRD=0.0425 NRS=0.0425 $X=611225 $Y=205750 $D=42
M73 VDDA VDDA VDDA VDDA pmos4 L=1.2e-05 W=1e-05 AD=8.5e-12 AS=8.5e-12 PD=1.17e-05 PS=1.17e-05 NRD=0.0425 NRS=0.0425 $X=625525 $Y=91050 $D=42
M74 VDDA VDDA VDDA VDDA pmos4 L=1.2e-05 W=1e-05 AD=8.5e-12 AS=8.5e-12 PD=1.17e-05 PS=1.17e-05 NRD=0.0425 NRS=0.0425 $X=625525 $Y=205750 $D=42
M75 VDDA VDDA VDDA VDDA pmos4 L=1.2e-05 W=1e-05 AD=8.5e-12 AS=8.5e-12 PD=1.17e-05 PS=1.17e-05 NRD=0.0425 NRS=0.0425 $X=639825 $Y=91050 $D=42
M76 VDDA VDDA VDDA VDDA pmos4 L=1.2e-05 W=1e-05 AD=8.5e-12 AS=8.5e-12 PD=1.17e-05 PS=1.17e-05 NRD=0.0425 NRS=0.0425 $X=639825 $Y=182450 $D=42
M77 VDDA VDDA VDDA VDDA pmos4 L=1.2e-05 W=1e-05 AD=8.5e-12 AS=8.5e-12 PD=1.17e-05 PS=1.17e-05 NRD=0.0425 NRS=0.0425 $X=639825 $Y=205750 $D=42
M78 VDDA VDDA VDDA VDDA pmos4 L=1.2e-05 W=1e-05 AD=8.5e-12 AS=8.5e-12 PD=1.17e-05 PS=1.17e-05 NRD=0.0425 NRS=0.0425 $X=654125 $Y=91050 $D=42
M79 VDDA VDDA VDDA VDDA pmos4 L=1.2e-05 W=1e-05 AD=8.5e-12 AS=8.5e-12 PD=1.17e-05 PS=1.17e-05 NRD=0.0425 NRS=0.0425 $X=654125 $Y=112550 $D=42
M80 VDDA VDDA VDDA VDDA pmos4 L=1.2e-05 W=1e-05 AD=8.5e-12 AS=8.5e-12 PD=1.17e-05 PS=1.17e-05 NRD=0.0425 NRS=0.0425 $X=654125 $Y=135850 $D=42
M81 VDDA VDDA VDDA VDDA pmos4 L=1.2e-05 W=1e-05 AD=8.5e-12 AS=8.5e-12 PD=1.17e-05 PS=1.17e-05 NRD=0.0425 NRS=0.0425 $X=654125 $Y=159150 $D=42
M82 VDDA VDDA VDDA VDDA pmos4 L=1.2e-05 W=1e-05 AD=8.5e-12 AS=8.5e-12 PD=1.17e-05 PS=1.17e-05 NRD=0.0425 NRS=0.0425 $X=654125 $Y=182450 $D=42
M83 VDDA VDDA VDDA VDDA pmos4 L=1.2e-05 W=1e-05 AD=8.5e-12 AS=8.5e-12 PD=1.17e-05 PS=1.17e-05 NRD=0.0425 NRS=0.0425 $X=654125 $Y=205750 $D=42
M84 22 22 22 22 pmos4 L=4e-06 W=1.25e-05 AD=1.0625e-11 AS=1.0625e-11 PD=1.42e-05 PS=1.42e-05 NRD=0.034 NRS=0.034 $X=716875 $Y=195275 $D=42
M85 22 22 22 22 pmos4 L=4e-06 W=1.25e-05 AD=1.0625e-11 AS=1.0625e-11 PD=1.42e-05 PS=1.42e-05 NRD=0.034 NRS=0.034 $X=716875 $Y=213925 $D=42
M86 22 22 22 22 pmos4 L=4e-06 W=1.25e-05 AD=1.0625e-11 AS=1.0625e-11 PD=1.42e-05 PS=1.42e-05 NRD=0.034 NRS=0.034 $X=773575 $Y=195275 $D=42
M87 22 22 22 22 pmos4 L=4e-06 W=1.25e-05 AD=1.0625e-11 AS=1.0625e-11 PD=1.42e-05 PS=1.42e-05 NRD=0.034 NRS=0.034 $X=773575 $Y=213925 $D=42
M88 31 11 VDDA VDDA pmos4 L=2e-05 W=1.25e-05 AD=1.0625e-11 AS=1.0625e-11 PD=1.42e-05 PS=1.42e-05 NRD=0.034 NRS=0.034 $X=302425 $Y=202350 $D=41
M89 11 11 VDDA VDDA pmos4 L=2e-05 W=1.25e-05 AD=1.0625e-11 AS=1.0625e-11 PD=1.42e-05 PS=1.42e-05 NRD=0.034 NRS=0.034 $X=302425 $Y=218650 $D=41
M90 11 11 VDDA VDDA pmos4 L=2e-05 W=1.25e-05 AD=1.0625e-11 AS=1.0625e-11 PD=1.42e-05 PS=1.42e-05 NRD=0.034 NRS=0.034 $X=324725 $Y=202350 $D=41
M91 31 11 VDDA VDDA pmos4 L=2e-05 W=1.25e-05 AD=1.0625e-11 AS=1.0625e-11 PD=1.42e-05 PS=1.42e-05 NRD=0.034 NRS=0.034 $X=324725 $Y=218650 $D=41
M92 11 11 VDDA VDDA pmos4 L=2e-05 W=1.25e-05 AD=1.0625e-11 AS=1.0625e-11 PD=1.42e-05 PS=1.42e-05 NRD=0.034 NRS=0.034 $X=347025 $Y=202350 $D=41
M93 31 11 VDDA VDDA pmos4 L=2e-05 W=1.25e-05 AD=1.0625e-11 AS=1.0625e-11 PD=1.42e-05 PS=1.42e-05 NRD=0.034 NRS=0.034 $X=347025 $Y=218650 $D=41
M94 31 11 VDDA VDDA pmos4 L=2e-05 W=1.25e-05 AD=1.0625e-11 AS=1.0625e-11 PD=1.42e-05 PS=1.42e-05 NRD=0.034 NRS=0.034 $X=369325 $Y=202350 $D=41
M95 11 11 VDDA VDDA pmos4 L=2e-05 W=1.25e-05 AD=1.0625e-11 AS=1.0625e-11 PD=1.42e-05 PS=1.42e-05 NRD=0.034 NRS=0.034 $X=369325 $Y=218650 $D=41
M96 2 20 VDDA VDDA pmos4 L=1.2e-05 W=1e-05 AD=8.5e-12 AS=8.5e-12 PD=1.17e-05 PS=1.17e-05 NRD=0.0425 NRS=0.0425 $X=482525 $Y=112550 $D=41
M97 1 20 VDDA VDDA pmos4 L=1.2e-05 W=1e-05 AD=8.5e-12 AS=8.5e-12 PD=1.17e-05 PS=1.17e-05 NRD=0.0425 NRS=0.0425 $X=482525 $Y=135850 $D=41
M98 2 20 VDDA VDDA pmos4 L=1.2e-05 W=1e-05 AD=8.5e-12 AS=8.5e-12 PD=1.17e-05 PS=1.17e-05 NRD=0.0425 NRS=0.0425 $X=482525 $Y=159150 $D=41
M99 1 20 VDDA VDDA pmos4 L=1.2e-05 W=1e-05 AD=8.5e-12 AS=8.5e-12 PD=1.17e-05 PS=1.17e-05 NRD=0.0425 NRS=0.0425 $X=482525 $Y=182450 $D=41
M100 1 20 VDDA VDDA pmos4 L=1.2e-05 W=1e-05 AD=8.5e-12 AS=8.5e-12 PD=1.17e-05 PS=1.17e-05 NRD=0.0425 NRS=0.0425 $X=496825 $Y=112550 $D=41
M101 2 20 VDDA VDDA pmos4 L=1.2e-05 W=1e-05 AD=8.5e-12 AS=8.5e-12 PD=1.17e-05 PS=1.17e-05 NRD=0.0425 NRS=0.0425 $X=496825 $Y=135850 $D=41
M102 1 20 VDDA VDDA pmos4 L=1.2e-05 W=1e-05 AD=8.5e-12 AS=8.5e-12 PD=1.17e-05 PS=1.17e-05 NRD=0.0425 NRS=0.0425 $X=496825 $Y=159150 $D=41
M103 2 20 VDDA VDDA pmos4 L=1.2e-05 W=1e-05 AD=8.5e-12 AS=8.5e-12 PD=1.17e-05 PS=1.17e-05 NRD=0.0425 NRS=0.0425 $X=496825 $Y=182450 $D=41
M104 VOUT 20 VDDA VDDA pmos4 L=1.2e-05 W=1e-05 AD=8.5e-12 AS=8.5e-12 PD=1.17e-05 PS=1.17e-05 NRD=0.0425 NRS=0.0425 $X=511125 $Y=112550 $D=41
M105 1 20 VDDA VDDA pmos4 L=1.2e-05 W=1e-05 AD=8.5e-12 AS=8.5e-12 PD=1.17e-05 PS=1.17e-05 NRD=0.0425 NRS=0.0425 $X=511125 $Y=135850 $D=41
M106 2 20 VDDA VDDA pmos4 L=1.2e-05 W=1e-05 AD=8.5e-12 AS=8.5e-12 PD=1.17e-05 PS=1.17e-05 NRD=0.0425 NRS=0.0425 $X=511125 $Y=159150 $D=41
M107 1 20 VDDA VDDA pmos4 L=1.2e-05 W=1e-05 AD=8.5e-12 AS=8.5e-12 PD=1.17e-05 PS=1.17e-05 NRD=0.0425 NRS=0.0425 $X=511125 $Y=182450 $D=41
M108 VOUT 20 VDDA VDDA pmos4 L=1.2e-05 W=1e-05 AD=8.5e-12 AS=8.5e-12 PD=1.17e-05 PS=1.17e-05 NRD=0.0425 NRS=0.0425 $X=525425 $Y=112550 $D=41
M109 20 20 VDDA VDDA pmos4 L=1.2e-05 W=1e-05 AD=8.5e-12 AS=8.5e-12 PD=1.17e-05 PS=1.17e-05 NRD=0.0425 NRS=0.0425 $X=525425 $Y=135850 $D=41
M110 1 20 VDDA VDDA pmos4 L=1.2e-05 W=1e-05 AD=8.5e-12 AS=8.5e-12 PD=1.17e-05 PS=1.17e-05 NRD=0.0425 NRS=0.0425 $X=525425 $Y=159150 $D=41
M111 2 20 VDDA VDDA pmos4 L=1.2e-05 W=1e-05 AD=8.5e-12 AS=8.5e-12 PD=1.17e-05 PS=1.17e-05 NRD=0.0425 NRS=0.0425 $X=525425 $Y=182450 $D=41
M112 VOUT 20 VDDA VDDA pmos4 L=1.2e-05 W=1e-05 AD=8.5e-12 AS=8.5e-12 PD=1.17e-05 PS=1.17e-05 NRD=0.0425 NRS=0.0425 $X=539725 $Y=112550 $D=41
M113 1 20 VDDA VDDA pmos4 L=1.2e-05 W=1e-05 AD=8.5e-12 AS=8.5e-12 PD=1.17e-05 PS=1.17e-05 NRD=0.0425 NRS=0.0425 $X=539725 $Y=135850 $D=41
M114 22 20 VDDA VDDA pmos4 L=1.2e-05 W=1e-05 AD=8.5e-12 AS=8.5e-12 PD=1.17e-05 PS=1.17e-05 NRD=0.0425 NRS=0.0425 $X=539725 $Y=159150 $D=41
M115 1 20 VDDA VDDA pmos4 L=1.2e-05 W=1e-05 AD=8.5e-12 AS=8.5e-12 PD=1.17e-05 PS=1.17e-05 NRD=0.0425 NRS=0.0425 $X=539725 $Y=182450 $D=41
M116 VOUT 20 VDDA VDDA pmos4 L=1.2e-05 W=1e-05 AD=8.5e-12 AS=8.5e-12 PD=1.17e-05 PS=1.17e-05 NRD=0.0425 NRS=0.0425 $X=554025 $Y=112550 $D=41
M117 2 20 VDDA VDDA pmos4 L=1.2e-05 W=1e-05 AD=8.5e-12 AS=8.5e-12 PD=1.17e-05 PS=1.17e-05 NRD=0.0425 NRS=0.0425 $X=554025 $Y=135850 $D=41
M118 22 20 VDDA VDDA pmos4 L=1.2e-05 W=1e-05 AD=8.5e-12 AS=8.5e-12 PD=1.17e-05 PS=1.17e-05 NRD=0.0425 NRS=0.0425 $X=554025 $Y=159150 $D=41
M119 2 20 VDDA VDDA pmos4 L=1.2e-05 W=1e-05 AD=8.5e-12 AS=8.5e-12 PD=1.17e-05 PS=1.17e-05 NRD=0.0425 NRS=0.0425 $X=554025 $Y=182450 $D=41
M120 VOUT 20 VDDA VDDA pmos4 L=1.2e-05 W=1e-05 AD=8.5e-12 AS=8.5e-12 PD=1.17e-05 PS=1.17e-05 NRD=0.0425 NRS=0.0425 $X=568325 $Y=112550 $D=41
M121 1 20 VDDA VDDA pmos4 L=1.2e-05 W=1e-05 AD=8.5e-12 AS=8.5e-12 PD=1.17e-05 PS=1.17e-05 NRD=0.0425 NRS=0.0425 $X=568325 $Y=135850 $D=41
M122 22 20 VDDA VDDA pmos4 L=1.2e-05 W=1e-05 AD=8.5e-12 AS=8.5e-12 PD=1.17e-05 PS=1.17e-05 NRD=0.0425 NRS=0.0425 $X=568325 $Y=159150 $D=41
M123 1 20 VDDA VDDA pmos4 L=1.2e-05 W=1e-05 AD=8.5e-12 AS=8.5e-12 PD=1.17e-05 PS=1.17e-05 NRD=0.0425 NRS=0.0425 $X=568325 $Y=182450 $D=41
M124 VOUT 20 VDDA VDDA pmos4 L=1.2e-05 W=1e-05 AD=8.5e-12 AS=8.5e-12 PD=1.17e-05 PS=1.17e-05 NRD=0.0425 NRS=0.0425 $X=582625 $Y=112550 $D=41
M125 2 20 VDDA VDDA pmos4 L=1.2e-05 W=1e-05 AD=8.5e-12 AS=8.5e-12 PD=1.17e-05 PS=1.17e-05 NRD=0.0425 NRS=0.0425 $X=582625 $Y=135850 $D=41
M126 22 20 VDDA VDDA pmos4 L=1.2e-05 W=1e-05 AD=8.5e-12 AS=8.5e-12 PD=1.17e-05 PS=1.17e-05 NRD=0.0425 NRS=0.0425 $X=582625 $Y=159150 $D=41
M127 2 20 VDDA VDDA pmos4 L=1.2e-05 W=1e-05 AD=8.5e-12 AS=8.5e-12 PD=1.17e-05 PS=1.17e-05 NRD=0.0425 NRS=0.0425 $X=582625 $Y=182450 $D=41
M128 VOUT 20 VDDA VDDA pmos4 L=1.2e-05 W=1e-05 AD=8.5e-12 AS=8.5e-12 PD=1.17e-05 PS=1.17e-05 NRD=0.0425 NRS=0.0425 $X=596925 $Y=112550 $D=41
M129 1 20 VDDA VDDA pmos4 L=1.2e-05 W=1e-05 AD=8.5e-12 AS=8.5e-12 PD=1.17e-05 PS=1.17e-05 NRD=0.0425 NRS=0.0425 $X=596925 $Y=135850 $D=41
M130 22 20 VDDA VDDA pmos4 L=1.2e-05 W=1e-05 AD=8.5e-12 AS=8.5e-12 PD=1.17e-05 PS=1.17e-05 NRD=0.0425 NRS=0.0425 $X=596925 $Y=159150 $D=41
M131 2 20 VDDA VDDA pmos4 L=1.2e-05 W=1e-05 AD=8.5e-12 AS=8.5e-12 PD=1.17e-05 PS=1.17e-05 NRD=0.0425 NRS=0.0425 $X=596925 $Y=182450 $D=41
M132 VOUT 20 VDDA VDDA pmos4 L=1.2e-05 W=1e-05 AD=8.5e-12 AS=8.5e-12 PD=1.17e-05 PS=1.17e-05 NRD=0.0425 NRS=0.0425 $X=611225 $Y=112550 $D=41
M133 2 20 VDDA VDDA pmos4 L=1.2e-05 W=1e-05 AD=8.5e-12 AS=8.5e-12 PD=1.17e-05 PS=1.17e-05 NRD=0.0425 NRS=0.0425 $X=611225 $Y=135850 $D=41
M134 20 20 VDDA VDDA pmos4 L=1.2e-05 W=1e-05 AD=8.5e-12 AS=8.5e-12 PD=1.17e-05 PS=1.17e-05 NRD=0.0425 NRS=0.0425 $X=611225 $Y=159150 $D=41
M135 2 20 VDDA VDDA pmos4 L=1.2e-05 W=1e-05 AD=8.5e-12 AS=8.5e-12 PD=1.17e-05 PS=1.17e-05 NRD=0.0425 NRS=0.0425 $X=611225 $Y=182450 $D=41
M136 VOUT 20 VDDA VDDA pmos4 L=1.2e-05 W=1e-05 AD=8.5e-12 AS=8.5e-12 PD=1.17e-05 PS=1.17e-05 NRD=0.0425 NRS=0.0425 $X=625525 $Y=112550 $D=41
M137 1 20 VDDA VDDA pmos4 L=1.2e-05 W=1e-05 AD=8.5e-12 AS=8.5e-12 PD=1.17e-05 PS=1.17e-05 NRD=0.0425 NRS=0.0425 $X=625525 $Y=135850 $D=41
M138 2 20 VDDA VDDA pmos4 L=1.2e-05 W=1e-05 AD=8.5e-12 AS=8.5e-12 PD=1.17e-05 PS=1.17e-05 NRD=0.0425 NRS=0.0425 $X=625525 $Y=159150 $D=41
M139 1 20 VDDA VDDA pmos4 L=1.2e-05 W=1e-05 AD=8.5e-12 AS=8.5e-12 PD=1.17e-05 PS=1.17e-05 NRD=0.0425 NRS=0.0425 $X=625525 $Y=182450 $D=41
M140 VOUT 20 VDDA VDDA pmos4 L=1.2e-05 W=1e-05 AD=8.5e-12 AS=8.5e-12 PD=1.17e-05 PS=1.17e-05 NRD=0.0425 NRS=0.0425 $X=639825 $Y=112550 $D=41
M141 2 20 VDDA VDDA pmos4 L=1.2e-05 W=1e-05 AD=8.5e-12 AS=8.5e-12 PD=1.17e-05 PS=1.17e-05 NRD=0.0425 NRS=0.0425 $X=639825 $Y=135850 $D=41
M142 1 20 VDDA VDDA pmos4 L=1.2e-05 W=1e-05 AD=8.5e-12 AS=8.5e-12 PD=1.17e-05 PS=1.17e-05 NRD=0.0425 NRS=0.0425 $X=639825 $Y=159150 $D=41
M143 33 18 22 22 pmos4 L=4e-06 W=1.25e-05 AD=1.0625e-11 AS=1.0625e-11 PD=1.42e-05 PS=1.42e-05 NRD=0.034 NRS=0.034 $X=742075 $Y=195275 $D=41
M144 32 VREF 22 22 pmos4 L=4e-06 W=1.25e-05 AD=1.0625e-11 AS=1.0625e-11 PD=1.42e-05 PS=1.42e-05 NRD=0.034 NRS=0.034 $X=742075 $Y=213925 $D=41
M145 32 VREF 22 22 pmos4 L=4e-06 W=1.25e-05 AD=1.0625e-11 AS=1.0625e-11 PD=1.42e-05 PS=1.42e-05 NRD=0.034 NRS=0.034 $X=767275 $Y=195275 $D=41
M146 33 18 22 22 pmos4 L=4e-06 W=1.25e-05 AD=1.0625e-11 AS=1.0625e-11 PD=1.42e-05 PS=1.42e-05 NRD=0.034 NRS=0.034 $X=767275 $Y=213925 $D=41
C147 GNDA BIAS $[cpolya] $A=750 $P=130 $X=145850 $Y=85650 $D=58
C148 GNDA VDDA $[cpolya] $A=750 $P=130 $X=201450 $Y=223900 $D=58
C149 VOUT 32 $[cpolya] $A=2306.26 $P=192.1 $X=712000 $Y=67275 $D=58
X150 8 9 19 14 27 28 VDDA GNDA chopper2 $T=48100 76450 0 0 $X=54800 $Y=94500
X151 VINN VINP 37 36 27 28 VDDA GNDA chopper2 $T=48100 115400 0 0 $X=54800 $Y=133450
X152 34 35 EXC2 EXC1 27 28 VDDA GNDA chopper2 $T=48100 156900 0 0 $X=54800 $Y=174950
X154 VDDD 28 CLK pmos4_CDNS_7807366010349 $T=59750 88650 0 270 $X=58550 $Y=86050
X155 VDDD 27 28 pmos4_CDNS_7807366010349 $T=64200 88650 0 270 $X=63000 $Y=86050
X156 GNDD 28 CLK nmos4_CDNS_7807366010348 $T=59750 82525 0 270 $X=59500 $Y=81325
X157 GNDD 27 28 nmos4_CDNS_7807366010348 $T=64200 82475 0 270 $X=63950 $Y=81275
X158 1 34 rpolyhc_CDNS_7807366010356 $T=131500 220950 0 180 $X=111300 $Y=215600
X159 35 2 rpolyhc_CDNS_7807366010356 $T=115300 227650 0 0 $X=111300 $Y=224300
X160 39 BIAS BIAS GNDA nmos4_CDNS_7807366010340 $T=165825 69525 1 270 $X=154875 $Y=58975
X169 2 30 36 pmos4_CDNS_7807366010352 $T=168225 163025 0 270 $X=167025 $Y=128475
X170 1 29 37 pmos4_CDNS_7807366010352 $T=168225 202525 0 270 $X=167025 $Y=167975
X171 1 29 37 pmos4_CDNS_7807366010352 $T=206325 163025 0 270 $X=205125 $Y=128475
X172 2 30 36 pmos4_CDNS_7807366010352 $T=206325 202525 0 270 $X=205125 $Y=167975
X174 GNDA 30 29 30 39 ICV_118 $T=208400 49625 0 0 $X=208000 $Y=49375
X175 GNDA 30 29 30 39 ICV_118 $T=221400 49625 0 0 $X=221000 $Y=49375
X176 GNDA 30 29 38 39 ICV_118 $T=234400 49625 0 0 $X=234000 $Y=49375
X177 GNDA 38 29 30 39 ICV_118 $T=247400 49625 0 0 $X=247000 $Y=49375
X178 GNDA 30 29 30 39 ICV_118 $T=260400 49625 0 0 $X=260000 $Y=49375
X179 GNDA 30 29 30 39 ICV_118 $T=273400 49625 0 0 $X=273000 $Y=49375
X190 11 16 16 VDDA pmos4_CDNS_7807366010338 $T=289625 171950 0 270 $X=288425 $Y=160750
X191 31 18 16 VDDA pmos4_CDNS_7807366010338 $T=340925 171950 0 270 $X=339725 $Y=160750
X212 GNDA 13 14 30 ICV_94 $T=321275 63100 1 0 $X=320875 $Y=49150
X213 GNDA 17 19 29 ICV_94 $T=321275 82800 1 0 $X=320875 $Y=68850
X214 GNDA 13 14 30 ICV_94 $T=342275 63100 1 0 $X=341875 $Y=49150
X215 GNDA 17 19 29 ICV_94 $T=342275 82800 1 0 $X=341875 $Y=68850
X216 8 18 BIAS GNDA nmos4_CDNS_7807366010343 $T=323875 105675 1 90 $X=323625 $Y=105275
X217 17 1 BIAS GNDA nmos4_CDNS_7807366010343 $T=323875 115325 1 90 $X=323625 $Y=114925
X218 13 2 BIAS GNDA nmos4_CDNS_7807366010343 $T=323875 124975 1 90 $X=323625 $Y=124575
X219 9 16 BIAS GNDA nmos4_CDNS_7807366010343 $T=323875 134625 1 90 $X=323625 $Y=134225
X232 VDDA ICV_87 $T=467375 101050 0 270 $X=466175 $Y=89850
X233 VDDA ICV_87 $T=467375 122550 0 270 $X=466175 $Y=111350
X234 VDDA ICV_87 $T=467375 145850 0 270 $X=466175 $Y=134650
X235 VDDA ICV_87 $T=467375 169150 0 270 $X=466175 $Y=157950
X236 VDDA ICV_87 $T=467375 192450 0 270 $X=466175 $Y=181250
X237 VDDA ICV_87 $T=467375 215750 0 270 $X=466175 $Y=204550
X310 22 32 33 VREF 18 ICV_110 $T=716025 207775 0 270 $X=714825 $Y=194075
X311 22 33 32 18 VREF ICV_110 $T=716025 226425 0 270 $X=714825 $Y=212725
X312 22 33 32 18 VREF ICV_110 $T=741225 207775 0 270 $X=740025 $Y=194075
X313 22 32 33 VREF 18 ICV_110 $T=741225 226425 0 270 $X=740025 $Y=212725
X324 40 rpolyhc_CDNS_7807366010358 $T=746200 56850 0 0 $X=742200 $Y=53400
X325 41 rpolyhc_CDNS_7807366010358 $T=832600 62500 0 0 $X=828600 $Y=59050
X326 VOUT 18 cpolyc_CDNS_7807366010337 $T=805775 72400 0 0 $X=804425 $Y=71050
X327 VOUT 18 cpolyc_CDNS_7807366010337 $T=805775 127900 0 0 $X=804425 $Y=126550
X328 VOUT 18 cpolyc_CDNS_7807366010337 $T=805775 183400 0 0 $X=804425 $Y=182050
X329 VOUT 18 cpolyc_CDNS_7807366010337 $T=862875 72400 0 0 $X=861525 $Y=71050
X330 VOUT 18 cpolyc_CDNS_7807366010337 $T=862875 127900 0 0 $X=861525 $Y=126550
X331 VOUT 18 cpolyc_CDNS_7807366010337 $T=862875 183400 0 0 $X=861525 $Y=182050
X332 VOUT 18 cpolyc_CDNS_7807366010337 $T=919975 72400 0 0 $X=918625 $Y=71050
X333 VOUT 18 cpolyc_CDNS_7807366010337 $T=919975 127900 0 0 $X=918625 $Y=126550
X334 VOUT 18 cpolyc_CDNS_7807366010337 $T=919975 183400 0 0 $X=918625 $Y=182050
.ENDS
***************************************
.SUBCKT nmos4_CDNS_78073660103102 1
** N=1 EP=1 IP=0 FDC=1
M0 1 1 1 1 nmos4 L=4e-06 W=2e-06 AD=1.7e-12 AS=1.7e-12 PD=3.7e-06 PS=3.7e-06 NRD=0.2125 NRS=0.2125 $X=0 $Y=850 $D=38
.ENDS
***************************************
.SUBCKT ICV_68 1
*.CALIBRE ICV_CELL 9
** N=1 EP=1 IP=2 FDC=2
X0 1 nmos4_CDNS_78073660103102 $T=0 0 0 0 $X=-400 $Y=-250
X1 1 nmos4_CDNS_78073660103102 $T=3250 0 0 0 $X=2850 $Y=-250
.ENDS
***************************************
.SUBCKT ICV_70 1
*.CALIBRE ICV_CELL 9
** N=1 EP=1 IP=2 FDC=4
X0 1 ICV_68 $T=0 0 0 0 $X=-400 $Y=-250
X1 1 ICV_68 $T=6500 0 0 0 $X=6100 $Y=-250
.ENDS
***************************************
.SUBCKT nmos4_CDNS_78073660103101
** N=4 EP=0 IP=0 FDC=0
.ENDS
***************************************
.SUBCKT ICV_69
** N=6 EP=0 IP=8 FDC=0
.ENDS
***************************************
.SUBCKT ICV_71
** N=10 EP=0 IP=12 FDC=0
.ENDS
***************************************
.SUBCKT ICV_72 1 2 3 4 5 6 7 8 9 10 11 12
** N=12 EP=12 IP=20 FDC=8
M0 1 1 1 12 nmos4 L=1e-05 W=2e-06 AD=1.7e-12 AS=1.7e-12 PD=3.7e-06 PS=3.7e-06 NRD=0.2125 NRS=0.2125 $X=0 $Y=850 $D=38
M1 3 1 2 12 nmos4 L=1e-05 W=2e-06 AD=1.7e-12 AS=1.7e-12 PD=3.7e-06 PS=3.7e-06 NRD=0.2125 NRS=0.2125 $X=3250 $Y=850 $D=37
M2 3 1 2 12 nmos4 L=1e-05 W=2e-06 AD=1.7e-12 AS=1.7e-12 PD=3.7e-06 PS=3.7e-06 NRD=0.2125 NRS=0.2125 $X=6500 $Y=850 $D=37
M3 5 1 4 12 nmos4 L=1e-05 W=2e-06 AD=1.7e-12 AS=1.7e-12 PD=3.7e-06 PS=3.7e-06 NRD=0.2125 NRS=0.2125 $X=9750 $Y=850 $D=37
M4 7 1 6 12 nmos4 L=1e-05 W=2e-06 AD=1.7e-12 AS=1.7e-12 PD=3.7e-06 PS=3.7e-06 NRD=0.2125 NRS=0.2125 $X=13000 $Y=850 $D=37
M5 9 1 8 12 nmos4 L=1e-05 W=2e-06 AD=1.7e-12 AS=1.7e-12 PD=3.7e-06 PS=3.7e-06 NRD=0.2125 NRS=0.2125 $X=16250 $Y=850 $D=37
M6 9 1 8 12 nmos4 L=1e-05 W=2e-06 AD=1.7e-12 AS=1.7e-12 PD=3.7e-06 PS=3.7e-06 NRD=0.2125 NRS=0.2125 $X=19500 $Y=850 $D=37
M7 11 1 10 12 nmos4 L=1e-05 W=2e-06 AD=1.7e-12 AS=1.7e-12 PD=3.7e-06 PS=3.7e-06 NRD=0.2125 NRS=0.2125 $X=22750 $Y=850 $D=37
.ENDS
***************************************
.SUBCKT cpolyc_CDNS_78073660103100 1 2
** N=2 EP=2 IP=0 FDC=1
C0 1 2 $[cpolya] $A=900 $P=120 $X=1800 $Y=1000 $D=58
.ENDS
***************************************
.SUBCKT nmos4_CDNS_7807366010396 1 2 3 4
** N=4 EP=4 IP=0 FDC=2
M0 2 3 1 4 nmos4 L=4e-06 W=1e-05 AD=5e-12 AS=8.5e-12 PD=1e-06 PS=1.17e-05 NRD=0.0425 NRS=0.0425 $X=0 $Y=850 $D=37
M1 1 3 2 4 nmos4 L=4e-06 W=1e-05 AD=8.5e-12 AS=5e-12 PD=1.17e-05 PS=1e-06 NRD=0.0425 NRS=0.0425 $X=0 $Y=5850 $D=37
.ENDS
***************************************
.SUBCKT pmos4_CDNS_78073660103104
** N=4 EP=0 IP=0 FDC=0
.ENDS
***************************************
.SUBCKT ICV_66 1 3 5
** N=6 EP=3 IP=8 FDC=1
M0 3 5 1 1 pmos4 L=5e-06 W=6e-06 AD=5.1e-12 AS=5.1e-12 PD=7.7e-06 PS=7.7e-06 NRD=0.0708333 NRS=0.0708333 $X=0 $Y=8150 $D=41
.ENDS
***************************************
.SUBCKT ICV_67 1 3 4 5 7
** N=8 EP=5 IP=12 FDC=3
M0 4 7 1 1 pmos4 L=5e-06 W=6e-06 AD=5.1e-12 AS=5.1e-12 PD=7.7e-06 PS=7.7e-06 NRD=0.0708333 NRS=0.0708333 $X=0 $Y=15450 $D=41
X1 1 3 7 ICV_66 $T=0 0 0 0 $X=-1200 $Y=-1200
X2 1 5 7 ICV_66 $T=0 14600 0 0 $X=-1200 $Y=13400
.ENDS
***************************************
.SUBCKT PD_C_CDNS_78073660103355
** N=1 EP=0 IP=0 FDC=0
.ENDS
***************************************
.SUBCKT nmos4_CDNS_7807366010395
** N=4 EP=0 IP=0 FDC=0
.ENDS
***************************************
.SUBCKT ICV_112
** N=6 EP=0 IP=8 FDC=0
.ENDS
***************************************
.SUBCKT ICV_113
** N=10 EP=0 IP=12 FDC=0
.ENDS
***************************************
.SUBCKT ICV_114
** N=12 EP=0 IP=20 FDC=0
.ENDS
***************************************
.SUBCKT PD_C_CDNS_78073660103354
** N=1 EP=0 IP=0 FDC=0
.ENDS
***************************************
.SUBCKT ND_C_CDNS_78073660103356
** N=2 EP=0 IP=0 FDC=0
.ENDS
***************************************
.SUBCKT pmos4_CDNS_78073660103103 1 2 3
** N=4 EP=3 IP=0 FDC=20
M0 2 3 1 1 pmos4 L=3.5e-07 W=1.5e-05 AD=7.5e-12 AS=1.275e-11 PD=1e-06 PS=1.67e-05 NRD=0.0283333 NRS=0.0283333 $X=0 $Y=850 $D=41
M1 1 3 2 1 pmos4 L=3.5e-07 W=1.5e-05 AD=7.5e-12 AS=7.5e-12 PD=1e-06 PS=1e-06 NRD=0.0283333 NRS=0.0283333 $X=0 $Y=2200 $D=41
M2 2 3 1 1 pmos4 L=3.5e-07 W=1.5e-05 AD=7.5e-12 AS=7.5e-12 PD=1e-06 PS=1e-06 NRD=0.0283333 NRS=0.0283333 $X=0 $Y=3550 $D=41
M3 1 3 2 1 pmos4 L=3.5e-07 W=1.5e-05 AD=7.5e-12 AS=7.5e-12 PD=1e-06 PS=1e-06 NRD=0.0283333 NRS=0.0283333 $X=0 $Y=4900 $D=41
M4 2 3 1 1 pmos4 L=3.5e-07 W=1.5e-05 AD=7.5e-12 AS=7.5e-12 PD=1e-06 PS=1e-06 NRD=0.0283333 NRS=0.0283333 $X=0 $Y=6250 $D=41
M5 1 3 2 1 pmos4 L=3.5e-07 W=1.5e-05 AD=7.5e-12 AS=7.5e-12 PD=1e-06 PS=1e-06 NRD=0.0283333 NRS=0.0283333 $X=0 $Y=7600 $D=41
M6 2 3 1 1 pmos4 L=3.5e-07 W=1.5e-05 AD=7.5e-12 AS=7.5e-12 PD=1e-06 PS=1e-06 NRD=0.0283333 NRS=0.0283333 $X=0 $Y=8950 $D=41
M7 1 3 2 1 pmos4 L=3.5e-07 W=1.5e-05 AD=7.5e-12 AS=7.5e-12 PD=1e-06 PS=1e-06 NRD=0.0283333 NRS=0.0283333 $X=0 $Y=10300 $D=41
M8 2 3 1 1 pmos4 L=3.5e-07 W=1.5e-05 AD=7.5e-12 AS=7.5e-12 PD=1e-06 PS=1e-06 NRD=0.0283333 NRS=0.0283333 $X=0 $Y=11650 $D=41
M9 1 3 2 1 pmos4 L=3.5e-07 W=1.5e-05 AD=7.5e-12 AS=7.5e-12 PD=1e-06 PS=1e-06 NRD=0.0283333 NRS=0.0283333 $X=0 $Y=13000 $D=41
M10 2 3 1 1 pmos4 L=3.5e-07 W=1.5e-05 AD=7.5e-12 AS=7.5e-12 PD=1e-06 PS=1e-06 NRD=0.0283333 NRS=0.0283333 $X=0 $Y=14350 $D=41
M11 1 3 2 1 pmos4 L=3.5e-07 W=1.5e-05 AD=7.5e-12 AS=7.5e-12 PD=1e-06 PS=1e-06 NRD=0.0283333 NRS=0.0283333 $X=0 $Y=15700 $D=41
M12 2 3 1 1 pmos4 L=3.5e-07 W=1.5e-05 AD=7.5e-12 AS=7.5e-12 PD=1e-06 PS=1e-06 NRD=0.0283333 NRS=0.0283333 $X=0 $Y=17050 $D=41
M13 1 3 2 1 pmos4 L=3.5e-07 W=1.5e-05 AD=7.5e-12 AS=7.5e-12 PD=1e-06 PS=1e-06 NRD=0.0283333 NRS=0.0283333 $X=0 $Y=18400 $D=41
M14 2 3 1 1 pmos4 L=3.5e-07 W=1.5e-05 AD=7.5e-12 AS=7.5e-12 PD=1e-06 PS=1e-06 NRD=0.0283333 NRS=0.0283333 $X=0 $Y=19750 $D=41
M15 1 3 2 1 pmos4 L=3.5e-07 W=1.5e-05 AD=7.5e-12 AS=7.5e-12 PD=1e-06 PS=1e-06 NRD=0.0283333 NRS=0.0283333 $X=0 $Y=21100 $D=41
M16 2 3 1 1 pmos4 L=3.5e-07 W=1.5e-05 AD=7.5e-12 AS=7.5e-12 PD=1e-06 PS=1e-06 NRD=0.0283333 NRS=0.0283333 $X=0 $Y=22450 $D=41
M17 1 3 2 1 pmos4 L=3.5e-07 W=1.5e-05 AD=7.5e-12 AS=7.5e-12 PD=1e-06 PS=1e-06 NRD=0.0283333 NRS=0.0283333 $X=0 $Y=23800 $D=41
M18 2 3 1 1 pmos4 L=3.5e-07 W=1.5e-05 AD=7.5e-12 AS=7.5e-12 PD=1e-06 PS=1e-06 NRD=0.0283333 NRS=0.0283333 $X=0 $Y=25150 $D=41
M19 1 3 2 1 pmos4 L=3.5e-07 W=1.5e-05 AD=1.275e-11 AS=7.5e-12 PD=1.67e-05 PS=1e-06 NRD=0.0283333 NRS=0.0283333 $X=0 $Y=26500 $D=41
.ENDS
***************************************
.SUBCKT ICV_62
** N=6 EP=0 IP=8 FDC=0
.ENDS
***************************************
.SUBCKT ICV_63
** N=10 EP=0 IP=12 FDC=0
.ENDS
***************************************
.SUBCKT ICV_64
** N=18 EP=0 IP=20 FDC=0
.ENDS
***************************************
.SUBCKT pmos4_CDNS_7807366010399
** N=5 EP=0 IP=0 FDC=0
.ENDS
***************************************
.SUBCKT cpolyc_CDNS_7807366010398 1 2
** N=2 EP=2 IP=0 FDC=1
C0 1 2 $[cpolya] $A=3500 $P=240 $X=1800 $Y=1000 $D=58
.ENDS
***************************************
.SUBCKT ND_C_CDNS_78073660103373
** N=1 EP=0 IP=0 FDC=0
.ENDS
***************************************
.SUBCKT INVX1 A vdd! gnd! Q
** N=4 EP=4 IP=0 FDC=2
M0 Q A gnd! gnd! nmos4 L=3.5e-07 W=4e-07 AD=5.7e-13 AS=1.45e-12 PD=2.8e-06 PS=6.5e-06 NRD=1.0625 NRS=1.0625 $X=1100 $Y=3450 $D=37
M1 Q A vdd! vdd! pmos4 L=3.5e-07 W=7e-07 AD=5.95e-13 AS=1.19e-12 PD=2.4e-06 PS=4.1e-06 NRD=0.607143 NRS=0.607143 $X=1250 $Y=6400 $D=41
.ENDS
***************************************
.SUBCKT pmos4_CDNS_7807366010394 1 2 3 5
** N=5 EP=4 IP=0 FDC=1
M0 2 3 1 5 pmos4 L=1e-06 W=2e-06 AD=1.7e-12 AS=1.7e-12 PD=3.7e-06 PS=3.7e-06 NRD=0.2125 NRS=0.2125 $X=0 $Y=850 $D=41
.ENDS
***************************************
.SUBCKT nmos4_CDNS_7807366010397 1 2 3 4
** N=4 EP=4 IP=0 FDC=1
M0 2 3 1 4 nmos4 L=1e-06 W=2e-06 AD=1.7e-12 AS=1.7e-12 PD=3.7e-06 PS=3.7e-06 NRD=0.2125 NRS=0.2125 $X=0 $Y=850 $D=37
.ENDS
***************************************
.SUBCKT ICV_111 1 2
*.CALIBRE ICV_CELL 9
** N=2 EP=2 IP=4 FDC=2
X0 1 2 cpolyc_CDNS_7807366010398 $T=0 0 0 0 $X=-1350 $Y=-1350
X1 1 2 cpolyc_CDNS_7807366010398 $T=76500 0 0 0 $X=75150 $Y=-1350
.ENDS
***************************************
.SUBCKT gmc_5_fc BIAS VDDA INP INN OUT S<2> S<1> S<0> GNDA
** N=57 EP=9 IP=777 FDC=462
R0 12 11 L=0.00150025 W=2e-06 $[rpolyh] $X=261575 $Y=20675 $D=18
D1 GNDA VDDA p_nwd AREA=4862.67 PJ=306.4 $X=5625 $Y=161600 $D=87
D2 GNDA 12 p_nwd AREA=567.997 PJ=100 $X=133900 $Y=156550 $D=87
D3 GNDA 11 p_nwd AREA=567.997 PJ=100 $X=133900 $Y=177700 $D=87
D4 GNDA 11 p_nwd AREA=567.997 PJ=100 $X=170000 $Y=156550 $D=87
D5 GNDA 12 p_nwd AREA=567.997 PJ=100 $X=170000 $Y=177700 $D=87
D6 GNDA VDDA p_nwd AREA=1448.4 PJ=153.2 $X=223525 $Y=170900 $D=87
D7 GNDA GNDA p_nwd AREA=114032 PJ=1689.95 $X=256925 $Y=16375 $D=87
D8 GNDA VDDA p_nwd AREA=188.312 PJ=77 $X=352900 $Y=199450 $D=87
D9 GNDA VDDA p_nwd AREA=63.125 PJ=32.7 $X=338050 $Y=199350 $D=87
M10 23 23 23 GNDA nmos4 L=1e-05 W=2e-06 AD=1.7e-12 AS=1.7e-12 PD=3.7e-06 PS=3.7e-06 NRD=0.2125 NRS=0.2125 $X=36550 $Y=55750 $D=38
M11 23 23 23 GNDA nmos4 L=1e-05 W=2e-06 AD=1.7e-12 AS=1.7e-12 PD=3.7e-06 PS=3.7e-06 NRD=0.2125 NRS=0.2125 $X=39800 $Y=55750 $D=38
M12 23 23 23 GNDA nmos4 L=1e-05 W=2e-06 AD=1.7e-12 AS=1.7e-12 PD=3.7e-06 PS=3.7e-06 NRD=0.2125 NRS=0.2125 $X=43050 $Y=55750 $D=38
M13 23 23 23 GNDA nmos4 L=1e-05 W=2e-06 AD=1.7e-12 AS=1.7e-12 PD=3.7e-06 PS=3.7e-06 NRD=0.2125 NRS=0.2125 $X=46300 $Y=55750 $D=38
M14 23 23 23 GNDA nmos4 L=1e-05 W=2e-06 AD=1.7e-12 AS=1.7e-12 PD=3.7e-06 PS=3.7e-06 NRD=0.2125 NRS=0.2125 $X=49550 $Y=25950 $D=38
M15 23 23 23 GNDA nmos4 L=1e-05 W=2e-06 AD=1.7e-12 AS=1.7e-12 PD=3.7e-06 PS=3.7e-06 NRD=0.2125 NRS=0.2125 $X=49550 $Y=40850 $D=38
M16 23 23 23 GNDA nmos4 L=1e-05 W=2e-06 AD=1.7e-12 AS=1.7e-12 PD=3.7e-06 PS=3.7e-06 NRD=0.2125 NRS=0.2125 $X=49550 $Y=55750 $D=38
M17 23 23 23 GNDA nmos4 L=1e-05 W=2e-06 AD=1.7e-12 AS=1.7e-12 PD=3.7e-06 PS=3.7e-06 NRD=0.2125 NRS=0.2125 $X=49550 $Y=70650 $D=38
M18 14 14 14 GNDA nmos4 L=2e-05 W=2e-06 AD=1.7e-12 AS=1.7e-12 PD=3.7e-06 PS=3.7e-06 NRD=0.2125 NRS=0.2125 $X=83100 $Y=15250 $D=38
M19 14 14 14 GNDA nmos4 L=2e-05 W=2e-06 AD=1.7e-12 AS=1.7e-12 PD=3.7e-06 PS=3.7e-06 NRD=0.2125 NRS=0.2125 $X=83100 $Y=40050 $D=38
M20 14 14 14 GNDA nmos4 L=2e-05 W=2e-06 AD=1.7e-12 AS=1.7e-12 PD=3.7e-06 PS=3.7e-06 NRD=0.2125 NRS=0.2125 $X=83100 $Y=64850 $D=38
M21 14 14 14 GNDA nmos4 L=2e-05 W=2e-06 AD=1.7e-12 AS=1.7e-12 PD=3.7e-06 PS=3.7e-06 NRD=0.2125 NRS=0.2125 $X=83100 $Y=89650 $D=38
M22 14 14 14 GNDA nmos4 L=2e-05 W=2e-06 AD=1.7e-12 AS=1.7e-12 PD=3.7e-06 PS=3.7e-06 NRD=0.2125 NRS=0.2125 $X=83100 $Y=114450 $D=38
M23 14 14 14 GNDA nmos4 L=2e-05 W=2e-06 AD=1.7e-12 AS=1.7e-12 PD=3.7e-06 PS=3.7e-06 NRD=0.2125 NRS=0.2125 $X=86350 $Y=64850 $D=38
M24 14 14 14 GNDA nmos4 L=2e-05 W=2e-06 AD=1.7e-12 AS=1.7e-12 PD=3.7e-06 PS=3.7e-06 NRD=0.2125 NRS=0.2125 $X=89600 $Y=64850 $D=38
M25 14 14 14 GNDA nmos4 L=2e-05 W=2e-06 AD=1.7e-12 AS=1.7e-12 PD=3.7e-06 PS=3.7e-06 NRD=0.2125 NRS=0.2125 $X=92850 $Y=64850 $D=38
M26 14 14 14 GNDA nmos4 L=2e-05 W=2e-06 AD=1.7e-12 AS=1.7e-12 PD=3.7e-06 PS=3.7e-06 NRD=0.2125 NRS=0.2125 $X=96100 $Y=64850 $D=38
M27 14 14 14 GNDA nmos4 L=2e-05 W=2e-06 AD=1.7e-12 AS=1.7e-12 PD=3.7e-06 PS=3.7e-06 NRD=0.2125 NRS=0.2125 $X=99350 $Y=64850 $D=38
M28 14 14 14 GNDA nmos4 L=2e-05 W=2e-06 AD=1.7e-12 AS=1.7e-12 PD=3.7e-06 PS=3.7e-06 NRD=0.2125 NRS=0.2125 $X=102600 $Y=64850 $D=38
M29 14 14 14 GNDA nmos4 L=2e-05 W=2e-06 AD=1.7e-12 AS=1.7e-12 PD=3.7e-06 PS=3.7e-06 NRD=0.2125 NRS=0.2125 $X=105850 $Y=64850 $D=38
M30 14 14 14 GNDA nmos4 L=2e-05 W=2e-06 AD=1.7e-12 AS=1.7e-12 PD=3.7e-06 PS=3.7e-06 NRD=0.2125 NRS=0.2125 $X=109100 $Y=64850 $D=38
M31 14 14 14 GNDA nmos4 L=2e-05 W=2e-06 AD=1.7e-12 AS=1.7e-12 PD=3.7e-06 PS=3.7e-06 NRD=0.2125 NRS=0.2125 $X=112350 $Y=64850 $D=38
M32 14 14 14 GNDA nmos4 L=2e-05 W=2e-06 AD=1.7e-12 AS=1.7e-12 PD=3.7e-06 PS=3.7e-06 NRD=0.2125 NRS=0.2125 $X=115600 $Y=64850 $D=38
M33 14 14 14 GNDA nmos4 L=2e-05 W=2e-06 AD=1.7e-12 AS=1.7e-12 PD=3.7e-06 PS=3.7e-06 NRD=0.2125 NRS=0.2125 $X=118850 $Y=64850 $D=38
M34 14 14 14 GNDA nmos4 L=2e-05 W=2e-06 AD=1.7e-12 AS=1.7e-12 PD=3.7e-06 PS=3.7e-06 NRD=0.2125 NRS=0.2125 $X=122100 $Y=64850 $D=38
M35 14 14 14 GNDA nmos4 L=2e-05 W=2e-06 AD=1.7e-12 AS=1.7e-12 PD=3.7e-06 PS=3.7e-06 NRD=0.2125 NRS=0.2125 $X=151350 $Y=15250 $D=38
M36 14 14 14 GNDA nmos4 L=2e-05 W=2e-06 AD=1.7e-12 AS=1.7e-12 PD=3.7e-06 PS=3.7e-06 NRD=0.2125 NRS=0.2125 $X=151350 $Y=40050 $D=38
M37 14 14 14 GNDA nmos4 L=2e-05 W=2e-06 AD=1.7e-12 AS=1.7e-12 PD=3.7e-06 PS=3.7e-06 NRD=0.2125 NRS=0.2125 $X=151350 $Y=64850 $D=38
M38 14 14 14 GNDA nmos4 L=2e-05 W=2e-06 AD=1.7e-12 AS=1.7e-12 PD=3.7e-06 PS=3.7e-06 NRD=0.2125 NRS=0.2125 $X=151350 $Y=89650 $D=38
M39 14 14 14 GNDA nmos4 L=2e-05 W=2e-06 AD=1.7e-12 AS=1.7e-12 PD=3.7e-06 PS=3.7e-06 NRD=0.2125 NRS=0.2125 $X=151350 $Y=114450 $D=38
M40 13 13 13 GNDA nmos4 L=2e-05 W=2e-06 AD=1.7e-12 AS=1.7e-12 PD=3.7e-06 PS=3.7e-06 NRD=0.2125 NRS=0.2125 $X=173750 $Y=15250 $D=38
M41 13 13 13 GNDA nmos4 L=2e-05 W=2e-06 AD=1.7e-12 AS=1.7e-12 PD=3.7e-06 PS=3.7e-06 NRD=0.2125 NRS=0.2125 $X=173750 $Y=40050 $D=38
M42 13 13 13 GNDA nmos4 L=2e-05 W=2e-06 AD=1.7e-12 AS=1.7e-12 PD=3.7e-06 PS=3.7e-06 NRD=0.2125 NRS=0.2125 $X=173750 $Y=64850 $D=38
M43 13 13 13 GNDA nmos4 L=2e-05 W=2e-06 AD=1.7e-12 AS=1.7e-12 PD=3.7e-06 PS=3.7e-06 NRD=0.2125 NRS=0.2125 $X=173750 $Y=89650 $D=38
M44 13 13 13 GNDA nmos4 L=2e-05 W=2e-06 AD=1.7e-12 AS=1.7e-12 PD=3.7e-06 PS=3.7e-06 NRD=0.2125 NRS=0.2125 $X=173750 $Y=114450 $D=38
M45 13 13 13 GNDA nmos4 L=2e-05 W=2e-06 AD=1.7e-12 AS=1.7e-12 PD=3.7e-06 PS=3.7e-06 NRD=0.2125 NRS=0.2125 $X=203000 $Y=64850 $D=38
M46 13 13 13 GNDA nmos4 L=2e-05 W=2e-06 AD=1.7e-12 AS=1.7e-12 PD=3.7e-06 PS=3.7e-06 NRD=0.2125 NRS=0.2125 $X=206250 $Y=64850 $D=38
M47 13 13 13 GNDA nmos4 L=2e-05 W=2e-06 AD=1.7e-12 AS=1.7e-12 PD=3.7e-06 PS=3.7e-06 NRD=0.2125 NRS=0.2125 $X=209500 $Y=64850 $D=38
M48 13 13 13 GNDA nmos4 L=2e-05 W=2e-06 AD=1.7e-12 AS=1.7e-12 PD=3.7e-06 PS=3.7e-06 NRD=0.2125 NRS=0.2125 $X=212750 $Y=64850 $D=38
M49 13 13 13 GNDA nmos4 L=2e-05 W=2e-06 AD=1.7e-12 AS=1.7e-12 PD=3.7e-06 PS=3.7e-06 NRD=0.2125 NRS=0.2125 $X=216000 $Y=64850 $D=38
M50 13 13 13 GNDA nmos4 L=2e-05 W=2e-06 AD=1.7e-12 AS=1.7e-12 PD=3.7e-06 PS=3.7e-06 NRD=0.2125 NRS=0.2125 $X=219250 $Y=64850 $D=38
M51 13 13 13 GNDA nmos4 L=2e-05 W=2e-06 AD=1.7e-12 AS=1.7e-12 PD=3.7e-06 PS=3.7e-06 NRD=0.2125 NRS=0.2125 $X=222500 $Y=64850 $D=38
M52 13 13 13 GNDA nmos4 L=2e-05 W=2e-06 AD=1.7e-12 AS=1.7e-12 PD=3.7e-06 PS=3.7e-06 NRD=0.2125 NRS=0.2125 $X=225750 $Y=64850 $D=38
M53 13 13 13 GNDA nmos4 L=2e-05 W=2e-06 AD=1.7e-12 AS=1.7e-12 PD=3.7e-06 PS=3.7e-06 NRD=0.2125 NRS=0.2125 $X=229000 $Y=64850 $D=38
M54 13 13 13 GNDA nmos4 L=2e-05 W=2e-06 AD=1.7e-12 AS=1.7e-12 PD=3.7e-06 PS=3.7e-06 NRD=0.2125 NRS=0.2125 $X=232250 $Y=64850 $D=38
M55 13 13 13 GNDA nmos4 L=2e-05 W=2e-06 AD=1.7e-12 AS=1.7e-12 PD=3.7e-06 PS=3.7e-06 NRD=0.2125 NRS=0.2125 $X=235500 $Y=64850 $D=38
M56 13 13 13 GNDA nmos4 L=2e-05 W=2e-06 AD=1.7e-12 AS=1.7e-12 PD=3.7e-06 PS=3.7e-06 NRD=0.2125 NRS=0.2125 $X=238750 $Y=64850 $D=38
M57 13 13 13 GNDA nmos4 L=2e-05 W=2e-06 AD=1.7e-12 AS=1.7e-12 PD=3.7e-06 PS=3.7e-06 NRD=0.2125 NRS=0.2125 $X=242000 $Y=15250 $D=38
M58 13 13 13 GNDA nmos4 L=2e-05 W=2e-06 AD=1.7e-12 AS=1.7e-12 PD=3.7e-06 PS=3.7e-06 NRD=0.2125 NRS=0.2125 $X=242000 $Y=40050 $D=38
M59 13 13 13 GNDA nmos4 L=2e-05 W=2e-06 AD=1.7e-12 AS=1.7e-12 PD=3.7e-06 PS=3.7e-06 NRD=0.2125 NRS=0.2125 $X=242000 $Y=64850 $D=38
M60 13 13 13 GNDA nmos4 L=2e-05 W=2e-06 AD=1.7e-12 AS=1.7e-12 PD=3.7e-06 PS=3.7e-06 NRD=0.2125 NRS=0.2125 $X=242000 $Y=89650 $D=38
M61 13 13 13 GNDA nmos4 L=2e-05 W=2e-06 AD=1.7e-12 AS=1.7e-12 PD=3.7e-06 PS=3.7e-06 NRD=0.2125 NRS=0.2125 $X=242000 $Y=114450 $D=38
M62 37 23 42 GNDA nmos4 L=1e-05 W=2e-06 AD=1.7e-12 AS=1.7e-12 PD=3.7e-06 PS=3.7e-06 NRD=0.2125 NRS=0.2125 $X=33300 $Y=25950 $D=37
M63 38 23 43 GNDA nmos4 L=1e-05 W=2e-06 AD=1.7e-12 AS=1.7e-12 PD=3.7e-06 PS=3.7e-06 NRD=0.2125 NRS=0.2125 $X=33300 $Y=40850 $D=37
M64 23 23 40 GNDA nmos4 L=1e-05 W=2e-06 AD=1.7e-12 AS=1.7e-12 PD=3.7e-06 PS=3.7e-06 NRD=0.2125 NRS=0.2125 $X=33300 $Y=55750 $D=37
M65 36 23 41 GNDA nmos4 L=1e-05 W=2e-06 AD=1.7e-12 AS=1.7e-12 PD=3.7e-06 PS=3.7e-06 NRD=0.2125 NRS=0.2125 $X=33300 $Y=70650 $D=37
M66 37 23 42 GNDA nmos4 L=1e-05 W=2e-06 AD=1.7e-12 AS=1.7e-12 PD=3.7e-06 PS=3.7e-06 NRD=0.2125 NRS=0.2125 $X=36550 $Y=25950 $D=37
M67 38 23 43 GNDA nmos4 L=1e-05 W=2e-06 AD=1.7e-12 AS=1.7e-12 PD=3.7e-06 PS=3.7e-06 NRD=0.2125 NRS=0.2125 $X=36550 $Y=40850 $D=37
M68 36 23 41 GNDA nmos4 L=1e-05 W=2e-06 AD=1.7e-12 AS=1.7e-12 PD=3.7e-06 PS=3.7e-06 NRD=0.2125 NRS=0.2125 $X=36550 $Y=70650 $D=37
M69 42 23 GNDA GNDA nmos4 L=1e-05 W=2e-06 AD=1.7e-12 AS=1.7e-12 PD=3.7e-06 PS=3.7e-06 NRD=0.2125 NRS=0.2125 $X=39800 $Y=25950 $D=37
M70 43 23 GNDA GNDA nmos4 L=1e-05 W=2e-06 AD=1.7e-12 AS=1.7e-12 PD=3.7e-06 PS=3.7e-06 NRD=0.2125 NRS=0.2125 $X=39800 $Y=40850 $D=37
M71 41 23 GNDA GNDA nmos4 L=1e-05 W=2e-06 AD=1.7e-12 AS=1.7e-12 PD=3.7e-06 PS=3.7e-06 NRD=0.2125 NRS=0.2125 $X=39800 $Y=70650 $D=37
M72 42 23 GNDA GNDA nmos4 L=1e-05 W=2e-06 AD=1.7e-12 AS=1.7e-12 PD=3.7e-06 PS=3.7e-06 NRD=0.2125 NRS=0.2125 $X=43050 $Y=25950 $D=37
M73 43 23 GNDA GNDA nmos4 L=1e-05 W=2e-06 AD=1.7e-12 AS=1.7e-12 PD=3.7e-06 PS=3.7e-06 NRD=0.2125 NRS=0.2125 $X=43050 $Y=40850 $D=37
M74 41 23 GNDA GNDA nmos4 L=1e-05 W=2e-06 AD=1.7e-12 AS=1.7e-12 PD=3.7e-06 PS=3.7e-06 NRD=0.2125 NRS=0.2125 $X=43050 $Y=70650 $D=37
M75 42 23 GNDA GNDA nmos4 L=1e-05 W=2e-06 AD=1.7e-12 AS=1.7e-12 PD=3.7e-06 PS=3.7e-06 NRD=0.2125 NRS=0.2125 $X=46300 $Y=25950 $D=37
M76 43 23 GNDA GNDA nmos4 L=1e-05 W=2e-06 AD=1.7e-12 AS=1.7e-12 PD=3.7e-06 PS=3.7e-06 NRD=0.2125 NRS=0.2125 $X=46300 $Y=40850 $D=37
M77 41 23 GNDA GNDA nmos4 L=1e-05 W=2e-06 AD=1.7e-12 AS=1.7e-12 PD=3.7e-06 PS=3.7e-06 NRD=0.2125 NRS=0.2125 $X=46300 $Y=70650 $D=37
M78 28 14 GNDA GNDA nmos4 L=2e-05 W=2e-06 AD=1.7e-12 AS=1.7e-12 PD=3.7e-06 PS=3.7e-06 NRD=0.2125 NRS=0.2125 $X=86350 $Y=15250 $D=37
M79 26 14 28 GNDA nmos4 L=2e-05 W=2e-06 AD=1.7e-12 AS=1.7e-12 PD=3.7e-06 PS=3.7e-06 NRD=0.2125 NRS=0.2125 $X=86350 $Y=40050 $D=37
M80 27 14 26 GNDA nmos4 L=2e-05 W=2e-06 AD=1.7e-12 AS=1.7e-12 PD=3.7e-06 PS=3.7e-06 NRD=0.2125 NRS=0.2125 $X=86350 $Y=89650 $D=37
M81 11 14 27 GNDA nmos4 L=2e-05 W=2e-06 AD=1.7e-12 AS=1.7e-12 PD=3.7e-06 PS=3.7e-06 NRD=0.2125 NRS=0.2125 $X=86350 $Y=114450 $D=37
M82 28 14 GNDA GNDA nmos4 L=2e-05 W=2e-06 AD=1.7e-12 AS=1.7e-12 PD=3.7e-06 PS=3.7e-06 NRD=0.2125 NRS=0.2125 $X=89600 $Y=15250 $D=37
M83 26 14 28 GNDA nmos4 L=2e-05 W=2e-06 AD=1.7e-12 AS=1.7e-12 PD=3.7e-06 PS=3.7e-06 NRD=0.2125 NRS=0.2125 $X=89600 $Y=40050 $D=37
M84 27 14 26 GNDA nmos4 L=2e-05 W=2e-06 AD=1.7e-12 AS=1.7e-12 PD=3.7e-06 PS=3.7e-06 NRD=0.2125 NRS=0.2125 $X=89600 $Y=89650 $D=37
M85 11 14 27 GNDA nmos4 L=2e-05 W=2e-06 AD=1.7e-12 AS=1.7e-12 PD=3.7e-06 PS=3.7e-06 NRD=0.2125 NRS=0.2125 $X=89600 $Y=114450 $D=37
M86 28 14 GNDA GNDA nmos4 L=2e-05 W=2e-06 AD=1.7e-12 AS=1.7e-12 PD=3.7e-06 PS=3.7e-06 NRD=0.2125 NRS=0.2125 $X=92850 $Y=15250 $D=37
M87 26 14 28 GNDA nmos4 L=2e-05 W=2e-06 AD=1.7e-12 AS=1.7e-12 PD=3.7e-06 PS=3.7e-06 NRD=0.2125 NRS=0.2125 $X=92850 $Y=40050 $D=37
M88 27 14 26 GNDA nmos4 L=2e-05 W=2e-06 AD=1.7e-12 AS=1.7e-12 PD=3.7e-06 PS=3.7e-06 NRD=0.2125 NRS=0.2125 $X=92850 $Y=89650 $D=37
M89 11 14 27 GNDA nmos4 L=2e-05 W=2e-06 AD=1.7e-12 AS=1.7e-12 PD=3.7e-06 PS=3.7e-06 NRD=0.2125 NRS=0.2125 $X=92850 $Y=114450 $D=37
M90 28 14 GNDA GNDA nmos4 L=2e-05 W=2e-06 AD=1.7e-12 AS=1.7e-12 PD=3.7e-06 PS=3.7e-06 NRD=0.2125 NRS=0.2125 $X=96100 $Y=15250 $D=37
M91 26 14 28 GNDA nmos4 L=2e-05 W=2e-06 AD=1.7e-12 AS=1.7e-12 PD=3.7e-06 PS=3.7e-06 NRD=0.2125 NRS=0.2125 $X=96100 $Y=40050 $D=37
M92 27 14 26 GNDA nmos4 L=2e-05 W=2e-06 AD=1.7e-12 AS=1.7e-12 PD=3.7e-06 PS=3.7e-06 NRD=0.2125 NRS=0.2125 $X=96100 $Y=89650 $D=37
M93 11 14 27 GNDA nmos4 L=2e-05 W=2e-06 AD=1.7e-12 AS=1.7e-12 PD=3.7e-06 PS=3.7e-06 NRD=0.2125 NRS=0.2125 $X=96100 $Y=114450 $D=37
M94 28 14 GNDA GNDA nmos4 L=2e-05 W=2e-06 AD=1.7e-12 AS=1.7e-12 PD=3.7e-06 PS=3.7e-06 NRD=0.2125 NRS=0.2125 $X=99350 $Y=15250 $D=37
M95 26 14 28 GNDA nmos4 L=2e-05 W=2e-06 AD=1.7e-12 AS=1.7e-12 PD=3.7e-06 PS=3.7e-06 NRD=0.2125 NRS=0.2125 $X=99350 $Y=40050 $D=37
M96 27 14 26 GNDA nmos4 L=2e-05 W=2e-06 AD=1.7e-12 AS=1.7e-12 PD=3.7e-06 PS=3.7e-06 NRD=0.2125 NRS=0.2125 $X=99350 $Y=89650 $D=37
M97 11 14 27 GNDA nmos4 L=2e-05 W=2e-06 AD=1.7e-12 AS=1.7e-12 PD=3.7e-06 PS=3.7e-06 NRD=0.2125 NRS=0.2125 $X=99350 $Y=114450 $D=37
M98 28 14 GNDA GNDA nmos4 L=2e-05 W=2e-06 AD=1.7e-12 AS=1.7e-12 PD=3.7e-06 PS=3.7e-06 NRD=0.2125 NRS=0.2125 $X=102600 $Y=15250 $D=37
M99 26 14 28 GNDA nmos4 L=2e-05 W=2e-06 AD=1.7e-12 AS=1.7e-12 PD=3.7e-06 PS=3.7e-06 NRD=0.2125 NRS=0.2125 $X=102600 $Y=40050 $D=37
M100 27 14 26 GNDA nmos4 L=2e-05 W=2e-06 AD=1.7e-12 AS=1.7e-12 PD=3.7e-06 PS=3.7e-06 NRD=0.2125 NRS=0.2125 $X=102600 $Y=89650 $D=37
M101 11 14 27 GNDA nmos4 L=2e-05 W=2e-06 AD=1.7e-12 AS=1.7e-12 PD=3.7e-06 PS=3.7e-06 NRD=0.2125 NRS=0.2125 $X=102600 $Y=114450 $D=37
M102 28 14 GNDA GNDA nmos4 L=2e-05 W=2e-06 AD=1.7e-12 AS=1.7e-12 PD=3.7e-06 PS=3.7e-06 NRD=0.2125 NRS=0.2125 $X=105850 $Y=15250 $D=37
M103 26 14 28 GNDA nmos4 L=2e-05 W=2e-06 AD=1.7e-12 AS=1.7e-12 PD=3.7e-06 PS=3.7e-06 NRD=0.2125 NRS=0.2125 $X=105850 $Y=40050 $D=37
M104 27 14 26 GNDA nmos4 L=2e-05 W=2e-06 AD=1.7e-12 AS=1.7e-12 PD=3.7e-06 PS=3.7e-06 NRD=0.2125 NRS=0.2125 $X=105850 $Y=89650 $D=37
M105 11 14 27 GNDA nmos4 L=2e-05 W=2e-06 AD=1.7e-12 AS=1.7e-12 PD=3.7e-06 PS=3.7e-06 NRD=0.2125 NRS=0.2125 $X=105850 $Y=114450 $D=37
M106 28 14 GNDA GNDA nmos4 L=2e-05 W=2e-06 AD=1.7e-12 AS=1.7e-12 PD=3.7e-06 PS=3.7e-06 NRD=0.2125 NRS=0.2125 $X=109100 $Y=15250 $D=37
M107 26 14 28 GNDA nmos4 L=2e-05 W=2e-06 AD=1.7e-12 AS=1.7e-12 PD=3.7e-06 PS=3.7e-06 NRD=0.2125 NRS=0.2125 $X=109100 $Y=40050 $D=37
M108 27 14 26 GNDA nmos4 L=2e-05 W=2e-06 AD=1.7e-12 AS=1.7e-12 PD=3.7e-06 PS=3.7e-06 NRD=0.2125 NRS=0.2125 $X=109100 $Y=89650 $D=37
M109 11 14 27 GNDA nmos4 L=2e-05 W=2e-06 AD=1.7e-12 AS=1.7e-12 PD=3.7e-06 PS=3.7e-06 NRD=0.2125 NRS=0.2125 $X=109100 $Y=114450 $D=37
M110 28 14 GNDA GNDA nmos4 L=2e-05 W=2e-06 AD=1.7e-12 AS=1.7e-12 PD=3.7e-06 PS=3.7e-06 NRD=0.2125 NRS=0.2125 $X=112350 $Y=15250 $D=37
M111 26 14 28 GNDA nmos4 L=2e-05 W=2e-06 AD=1.7e-12 AS=1.7e-12 PD=3.7e-06 PS=3.7e-06 NRD=0.2125 NRS=0.2125 $X=112350 $Y=40050 $D=37
M112 27 14 26 GNDA nmos4 L=2e-05 W=2e-06 AD=1.7e-12 AS=1.7e-12 PD=3.7e-06 PS=3.7e-06 NRD=0.2125 NRS=0.2125 $X=112350 $Y=89650 $D=37
M113 11 14 27 GNDA nmos4 L=2e-05 W=2e-06 AD=1.7e-12 AS=1.7e-12 PD=3.7e-06 PS=3.7e-06 NRD=0.2125 NRS=0.2125 $X=112350 $Y=114450 $D=37
M114 28 14 GNDA GNDA nmos4 L=2e-05 W=2e-06 AD=1.7e-12 AS=1.7e-12 PD=3.7e-06 PS=3.7e-06 NRD=0.2125 NRS=0.2125 $X=115600 $Y=15250 $D=37
M115 26 14 28 GNDA nmos4 L=2e-05 W=2e-06 AD=1.7e-12 AS=1.7e-12 PD=3.7e-06 PS=3.7e-06 NRD=0.2125 NRS=0.2125 $X=115600 $Y=40050 $D=37
M116 27 14 26 GNDA nmos4 L=2e-05 W=2e-06 AD=1.7e-12 AS=1.7e-12 PD=3.7e-06 PS=3.7e-06 NRD=0.2125 NRS=0.2125 $X=115600 $Y=89650 $D=37
M117 11 14 27 GNDA nmos4 L=2e-05 W=2e-06 AD=1.7e-12 AS=1.7e-12 PD=3.7e-06 PS=3.7e-06 NRD=0.2125 NRS=0.2125 $X=115600 $Y=114450 $D=37
M118 28 14 GNDA GNDA nmos4 L=2e-05 W=2e-06 AD=1.7e-12 AS=1.7e-12 PD=3.7e-06 PS=3.7e-06 NRD=0.2125 NRS=0.2125 $X=118850 $Y=15250 $D=37
M119 26 14 28 GNDA nmos4 L=2e-05 W=2e-06 AD=1.7e-12 AS=1.7e-12 PD=3.7e-06 PS=3.7e-06 NRD=0.2125 NRS=0.2125 $X=118850 $Y=40050 $D=37
M120 27 14 26 GNDA nmos4 L=2e-05 W=2e-06 AD=1.7e-12 AS=1.7e-12 PD=3.7e-06 PS=3.7e-06 NRD=0.2125 NRS=0.2125 $X=118850 $Y=89650 $D=37
M121 11 14 27 GNDA nmos4 L=2e-05 W=2e-06 AD=1.7e-12 AS=1.7e-12 PD=3.7e-06 PS=3.7e-06 NRD=0.2125 NRS=0.2125 $X=118850 $Y=114450 $D=37
M122 28 14 GNDA GNDA nmos4 L=2e-05 W=2e-06 AD=1.7e-12 AS=1.7e-12 PD=3.7e-06 PS=3.7e-06 NRD=0.2125 NRS=0.2125 $X=122100 $Y=15250 $D=37
M123 26 14 28 GNDA nmos4 L=2e-05 W=2e-06 AD=1.7e-12 AS=1.7e-12 PD=3.7e-06 PS=3.7e-06 NRD=0.2125 NRS=0.2125 $X=122100 $Y=40050 $D=37
M124 27 14 26 GNDA nmos4 L=2e-05 W=2e-06 AD=1.7e-12 AS=1.7e-12 PD=3.7e-06 PS=3.7e-06 NRD=0.2125 NRS=0.2125 $X=122100 $Y=89650 $D=37
M125 11 14 27 GNDA nmos4 L=2e-05 W=2e-06 AD=1.7e-12 AS=1.7e-12 PD=3.7e-06 PS=3.7e-06 NRD=0.2125 NRS=0.2125 $X=122100 $Y=114450 $D=37
M126 28 14 GNDA GNDA nmos4 L=2e-05 W=2e-06 AD=1.7e-12 AS=1.7e-12 PD=3.7e-06 PS=3.7e-06 NRD=0.2125 NRS=0.2125 $X=125350 $Y=15250 $D=37
M127 26 14 28 GNDA nmos4 L=2e-05 W=2e-06 AD=1.7e-12 AS=1.7e-12 PD=3.7e-06 PS=3.7e-06 NRD=0.2125 NRS=0.2125 $X=125350 $Y=40050 $D=37
M128 10 14 44 GNDA nmos4 L=2e-05 W=2e-06 AD=1.7e-12 AS=1.7e-12 PD=3.7e-06 PS=3.7e-06 NRD=0.2125 NRS=0.2125 $X=125350 $Y=64850 $D=37
M129 27 14 26 GNDA nmos4 L=2e-05 W=2e-06 AD=1.7e-12 AS=1.7e-12 PD=3.7e-06 PS=3.7e-06 NRD=0.2125 NRS=0.2125 $X=125350 $Y=89650 $D=37
M130 11 14 27 GNDA nmos4 L=2e-05 W=2e-06 AD=1.7e-12 AS=1.7e-12 PD=3.7e-06 PS=3.7e-06 NRD=0.2125 NRS=0.2125 $X=125350 $Y=114450 $D=37
M131 28 14 GNDA GNDA nmos4 L=2e-05 W=2e-06 AD=1.7e-12 AS=1.7e-12 PD=3.7e-06 PS=3.7e-06 NRD=0.2125 NRS=0.2125 $X=128600 $Y=15250 $D=37
M132 26 14 28 GNDA nmos4 L=2e-05 W=2e-06 AD=1.7e-12 AS=1.7e-12 PD=3.7e-06 PS=3.7e-06 NRD=0.2125 NRS=0.2125 $X=128600 $Y=40050 $D=37
M133 44 14 45 GNDA nmos4 L=2e-05 W=2e-06 AD=1.7e-12 AS=1.7e-12 PD=3.7e-06 PS=3.7e-06 NRD=0.2125 NRS=0.2125 $X=128600 $Y=64850 $D=37
M134 27 14 26 GNDA nmos4 L=2e-05 W=2e-06 AD=1.7e-12 AS=1.7e-12 PD=3.7e-06 PS=3.7e-06 NRD=0.2125 NRS=0.2125 $X=128600 $Y=89650 $D=37
M135 11 14 27 GNDA nmos4 L=2e-05 W=2e-06 AD=1.7e-12 AS=1.7e-12 PD=3.7e-06 PS=3.7e-06 NRD=0.2125 NRS=0.2125 $X=128600 $Y=114450 $D=37
M136 28 14 GNDA GNDA nmos4 L=2e-05 W=2e-06 AD=1.7e-12 AS=1.7e-12 PD=3.7e-06 PS=3.7e-06 NRD=0.2125 NRS=0.2125 $X=131850 $Y=15250 $D=37
M137 26 14 28 GNDA nmos4 L=2e-05 W=2e-06 AD=1.7e-12 AS=1.7e-12 PD=3.7e-06 PS=3.7e-06 NRD=0.2125 NRS=0.2125 $X=131850 $Y=40050 $D=37
M138 45 14 46 GNDA nmos4 L=2e-05 W=2e-06 AD=1.7e-12 AS=1.7e-12 PD=3.7e-06 PS=3.7e-06 NRD=0.2125 NRS=0.2125 $X=131850 $Y=64850 $D=37
M139 27 14 26 GNDA nmos4 L=2e-05 W=2e-06 AD=1.7e-12 AS=1.7e-12 PD=3.7e-06 PS=3.7e-06 NRD=0.2125 NRS=0.2125 $X=131850 $Y=89650 $D=37
M140 11 14 27 GNDA nmos4 L=2e-05 W=2e-06 AD=1.7e-12 AS=1.7e-12 PD=3.7e-06 PS=3.7e-06 NRD=0.2125 NRS=0.2125 $X=131850 $Y=114450 $D=37
M141 28 14 GNDA GNDA nmos4 L=2e-05 W=2e-06 AD=1.7e-12 AS=1.7e-12 PD=3.7e-06 PS=3.7e-06 NRD=0.2125 NRS=0.2125 $X=135100 $Y=15250 $D=37
M142 26 14 28 GNDA nmos4 L=2e-05 W=2e-06 AD=1.7e-12 AS=1.7e-12 PD=3.7e-06 PS=3.7e-06 NRD=0.2125 NRS=0.2125 $X=135100 $Y=40050 $D=37
M143 46 14 47 GNDA nmos4 L=2e-05 W=2e-06 AD=1.7e-12 AS=1.7e-12 PD=3.7e-06 PS=3.7e-06 NRD=0.2125 NRS=0.2125 $X=135100 $Y=64850 $D=37
M144 27 14 26 GNDA nmos4 L=2e-05 W=2e-06 AD=1.7e-12 AS=1.7e-12 PD=3.7e-06 PS=3.7e-06 NRD=0.2125 NRS=0.2125 $X=135100 $Y=89650 $D=37
M145 11 14 27 GNDA nmos4 L=2e-05 W=2e-06 AD=1.7e-12 AS=1.7e-12 PD=3.7e-06 PS=3.7e-06 NRD=0.2125 NRS=0.2125 $X=135100 $Y=114450 $D=37
M146 28 14 GNDA GNDA nmos4 L=2e-05 W=2e-06 AD=1.7e-12 AS=1.7e-12 PD=3.7e-06 PS=3.7e-06 NRD=0.2125 NRS=0.2125 $X=138350 $Y=15250 $D=37
M147 26 14 28 GNDA nmos4 L=2e-05 W=2e-06 AD=1.7e-12 AS=1.7e-12 PD=3.7e-06 PS=3.7e-06 NRD=0.2125 NRS=0.2125 $X=138350 $Y=40050 $D=37
M148 47 14 48 GNDA nmos4 L=2e-05 W=2e-06 AD=1.7e-12 AS=1.7e-12 PD=3.7e-06 PS=3.7e-06 NRD=0.2125 NRS=0.2125 $X=138350 $Y=64850 $D=37
M149 27 14 26 GNDA nmos4 L=2e-05 W=2e-06 AD=1.7e-12 AS=1.7e-12 PD=3.7e-06 PS=3.7e-06 NRD=0.2125 NRS=0.2125 $X=138350 $Y=89650 $D=37
M150 11 14 27 GNDA nmos4 L=2e-05 W=2e-06 AD=1.7e-12 AS=1.7e-12 PD=3.7e-06 PS=3.7e-06 NRD=0.2125 NRS=0.2125 $X=138350 $Y=114450 $D=37
M151 28 14 GNDA GNDA nmos4 L=2e-05 W=2e-06 AD=1.7e-12 AS=1.7e-12 PD=3.7e-06 PS=3.7e-06 NRD=0.2125 NRS=0.2125 $X=141600 $Y=15250 $D=37
M152 26 14 28 GNDA nmos4 L=2e-05 W=2e-06 AD=1.7e-12 AS=1.7e-12 PD=3.7e-06 PS=3.7e-06 NRD=0.2125 NRS=0.2125 $X=141600 $Y=40050 $D=37
M153 48 14 49 GNDA nmos4 L=2e-05 W=2e-06 AD=1.7e-12 AS=1.7e-12 PD=3.7e-06 PS=3.7e-06 NRD=0.2125 NRS=0.2125 $X=141600 $Y=64850 $D=37
M154 27 14 26 GNDA nmos4 L=2e-05 W=2e-06 AD=1.7e-12 AS=1.7e-12 PD=3.7e-06 PS=3.7e-06 NRD=0.2125 NRS=0.2125 $X=141600 $Y=89650 $D=37
M155 11 14 27 GNDA nmos4 L=2e-05 W=2e-06 AD=1.7e-12 AS=1.7e-12 PD=3.7e-06 PS=3.7e-06 NRD=0.2125 NRS=0.2125 $X=141600 $Y=114450 $D=37
M156 28 14 GNDA GNDA nmos4 L=2e-05 W=2e-06 AD=1.7e-12 AS=1.7e-12 PD=3.7e-06 PS=3.7e-06 NRD=0.2125 NRS=0.2125 $X=144850 $Y=15250 $D=37
M157 26 14 28 GNDA nmos4 L=2e-05 W=2e-06 AD=1.7e-12 AS=1.7e-12 PD=3.7e-06 PS=3.7e-06 NRD=0.2125 NRS=0.2125 $X=144850 $Y=40050 $D=37
M158 49 14 50 GNDA nmos4 L=2e-05 W=2e-06 AD=1.7e-12 AS=1.7e-12 PD=3.7e-06 PS=3.7e-06 NRD=0.2125 NRS=0.2125 $X=144850 $Y=64850 $D=37
M159 27 14 26 GNDA nmos4 L=2e-05 W=2e-06 AD=1.7e-12 AS=1.7e-12 PD=3.7e-06 PS=3.7e-06 NRD=0.2125 NRS=0.2125 $X=144850 $Y=89650 $D=37
M160 11 14 27 GNDA nmos4 L=2e-05 W=2e-06 AD=1.7e-12 AS=1.7e-12 PD=3.7e-06 PS=3.7e-06 NRD=0.2125 NRS=0.2125 $X=144850 $Y=114450 $D=37
M161 28 14 GNDA GNDA nmos4 L=2e-05 W=2e-06 AD=1.7e-12 AS=1.7e-12 PD=3.7e-06 PS=3.7e-06 NRD=0.2125 NRS=0.2125 $X=148100 $Y=15250 $D=37
M162 26 14 28 GNDA nmos4 L=2e-05 W=2e-06 AD=1.7e-12 AS=1.7e-12 PD=3.7e-06 PS=3.7e-06 NRD=0.2125 NRS=0.2125 $X=148100 $Y=40050 $D=37
M163 50 14 GNDA GNDA nmos4 L=2e-05 W=2e-06 AD=1.7e-12 AS=1.7e-12 PD=3.7e-06 PS=3.7e-06 NRD=0.2125 NRS=0.2125 $X=148100 $Y=64850 $D=37
M164 27 14 26 GNDA nmos4 L=2e-05 W=2e-06 AD=1.7e-12 AS=1.7e-12 PD=3.7e-06 PS=3.7e-06 NRD=0.2125 NRS=0.2125 $X=148100 $Y=89650 $D=37
M165 11 14 27 GNDA nmos4 L=2e-05 W=2e-06 AD=1.7e-12 AS=1.7e-12 PD=3.7e-06 PS=3.7e-06 NRD=0.2125 NRS=0.2125 $X=148100 $Y=114450 $D=37
M166 29 13 GNDA GNDA nmos4 L=2e-05 W=2e-06 AD=1.7e-12 AS=1.7e-12 PD=3.7e-06 PS=3.7e-06 NRD=0.2125 NRS=0.2125 $X=177000 $Y=15250 $D=37
M167 31 13 29 GNDA nmos4 L=2e-05 W=2e-06 AD=1.7e-12 AS=1.7e-12 PD=3.7e-06 PS=3.7e-06 NRD=0.2125 NRS=0.2125 $X=177000 $Y=40050 $D=37
M168 51 13 GNDA GNDA nmos4 L=2e-05 W=2e-06 AD=1.7e-12 AS=1.7e-12 PD=3.7e-06 PS=3.7e-06 NRD=0.2125 NRS=0.2125 $X=177000 $Y=64850 $D=37
M169 30 13 31 GNDA nmos4 L=2e-05 W=2e-06 AD=1.7e-12 AS=1.7e-12 PD=3.7e-06 PS=3.7e-06 NRD=0.2125 NRS=0.2125 $X=177000 $Y=89650 $D=37
M170 12 13 30 GNDA nmos4 L=2e-05 W=2e-06 AD=1.7e-12 AS=1.7e-12 PD=3.7e-06 PS=3.7e-06 NRD=0.2125 NRS=0.2125 $X=177000 $Y=114450 $D=37
M171 29 13 GNDA GNDA nmos4 L=2e-05 W=2e-06 AD=1.7e-12 AS=1.7e-12 PD=3.7e-06 PS=3.7e-06 NRD=0.2125 NRS=0.2125 $X=180250 $Y=15250 $D=37
M172 31 13 29 GNDA nmos4 L=2e-05 W=2e-06 AD=1.7e-12 AS=1.7e-12 PD=3.7e-06 PS=3.7e-06 NRD=0.2125 NRS=0.2125 $X=180250 $Y=40050 $D=37
M173 52 13 51 GNDA nmos4 L=2e-05 W=2e-06 AD=1.7e-12 AS=1.7e-12 PD=3.7e-06 PS=3.7e-06 NRD=0.2125 NRS=0.2125 $X=180250 $Y=64850 $D=37
M174 30 13 31 GNDA nmos4 L=2e-05 W=2e-06 AD=1.7e-12 AS=1.7e-12 PD=3.7e-06 PS=3.7e-06 NRD=0.2125 NRS=0.2125 $X=180250 $Y=89650 $D=37
M175 12 13 30 GNDA nmos4 L=2e-05 W=2e-06 AD=1.7e-12 AS=1.7e-12 PD=3.7e-06 PS=3.7e-06 NRD=0.2125 NRS=0.2125 $X=180250 $Y=114450 $D=37
M176 29 13 GNDA GNDA nmos4 L=2e-05 W=2e-06 AD=1.7e-12 AS=1.7e-12 PD=3.7e-06 PS=3.7e-06 NRD=0.2125 NRS=0.2125 $X=183500 $Y=15250 $D=37
M177 31 13 29 GNDA nmos4 L=2e-05 W=2e-06 AD=1.7e-12 AS=1.7e-12 PD=3.7e-06 PS=3.7e-06 NRD=0.2125 NRS=0.2125 $X=183500 $Y=40050 $D=37
M178 53 13 52 GNDA nmos4 L=2e-05 W=2e-06 AD=1.7e-12 AS=1.7e-12 PD=3.7e-06 PS=3.7e-06 NRD=0.2125 NRS=0.2125 $X=183500 $Y=64850 $D=37
M179 30 13 31 GNDA nmos4 L=2e-05 W=2e-06 AD=1.7e-12 AS=1.7e-12 PD=3.7e-06 PS=3.7e-06 NRD=0.2125 NRS=0.2125 $X=183500 $Y=89650 $D=37
M180 12 13 30 GNDA nmos4 L=2e-05 W=2e-06 AD=1.7e-12 AS=1.7e-12 PD=3.7e-06 PS=3.7e-06 NRD=0.2125 NRS=0.2125 $X=183500 $Y=114450 $D=37
M181 29 13 GNDA GNDA nmos4 L=2e-05 W=2e-06 AD=1.7e-12 AS=1.7e-12 PD=3.7e-06 PS=3.7e-06 NRD=0.2125 NRS=0.2125 $X=186750 $Y=15250 $D=37
M182 31 13 29 GNDA nmos4 L=2e-05 W=2e-06 AD=1.7e-12 AS=1.7e-12 PD=3.7e-06 PS=3.7e-06 NRD=0.2125 NRS=0.2125 $X=186750 $Y=40050 $D=37
M183 54 13 53 GNDA nmos4 L=2e-05 W=2e-06 AD=1.7e-12 AS=1.7e-12 PD=3.7e-06 PS=3.7e-06 NRD=0.2125 NRS=0.2125 $X=186750 $Y=64850 $D=37
M184 30 13 31 GNDA nmos4 L=2e-05 W=2e-06 AD=1.7e-12 AS=1.7e-12 PD=3.7e-06 PS=3.7e-06 NRD=0.2125 NRS=0.2125 $X=186750 $Y=89650 $D=37
M185 12 13 30 GNDA nmos4 L=2e-05 W=2e-06 AD=1.7e-12 AS=1.7e-12 PD=3.7e-06 PS=3.7e-06 NRD=0.2125 NRS=0.2125 $X=186750 $Y=114450 $D=37
M186 29 13 GNDA GNDA nmos4 L=2e-05 W=2e-06 AD=1.7e-12 AS=1.7e-12 PD=3.7e-06 PS=3.7e-06 NRD=0.2125 NRS=0.2125 $X=190000 $Y=15250 $D=37
M187 31 13 29 GNDA nmos4 L=2e-05 W=2e-06 AD=1.7e-12 AS=1.7e-12 PD=3.7e-06 PS=3.7e-06 NRD=0.2125 NRS=0.2125 $X=190000 $Y=40050 $D=37
M188 55 13 54 GNDA nmos4 L=2e-05 W=2e-06 AD=1.7e-12 AS=1.7e-12 PD=3.7e-06 PS=3.7e-06 NRD=0.2125 NRS=0.2125 $X=190000 $Y=64850 $D=37
M189 30 13 31 GNDA nmos4 L=2e-05 W=2e-06 AD=1.7e-12 AS=1.7e-12 PD=3.7e-06 PS=3.7e-06 NRD=0.2125 NRS=0.2125 $X=190000 $Y=89650 $D=37
M190 12 13 30 GNDA nmos4 L=2e-05 W=2e-06 AD=1.7e-12 AS=1.7e-12 PD=3.7e-06 PS=3.7e-06 NRD=0.2125 NRS=0.2125 $X=190000 $Y=114450 $D=37
M191 29 13 GNDA GNDA nmos4 L=2e-05 W=2e-06 AD=1.7e-12 AS=1.7e-12 PD=3.7e-06 PS=3.7e-06 NRD=0.2125 NRS=0.2125 $X=193250 $Y=15250 $D=37
M192 31 13 29 GNDA nmos4 L=2e-05 W=2e-06 AD=1.7e-12 AS=1.7e-12 PD=3.7e-06 PS=3.7e-06 NRD=0.2125 NRS=0.2125 $X=193250 $Y=40050 $D=37
M193 56 13 55 GNDA nmos4 L=2e-05 W=2e-06 AD=1.7e-12 AS=1.7e-12 PD=3.7e-06 PS=3.7e-06 NRD=0.2125 NRS=0.2125 $X=193250 $Y=64850 $D=37
M194 30 13 31 GNDA nmos4 L=2e-05 W=2e-06 AD=1.7e-12 AS=1.7e-12 PD=3.7e-06 PS=3.7e-06 NRD=0.2125 NRS=0.2125 $X=193250 $Y=89650 $D=37
M195 12 13 30 GNDA nmos4 L=2e-05 W=2e-06 AD=1.7e-12 AS=1.7e-12 PD=3.7e-06 PS=3.7e-06 NRD=0.2125 NRS=0.2125 $X=193250 $Y=114450 $D=37
M196 29 13 GNDA GNDA nmos4 L=2e-05 W=2e-06 AD=1.7e-12 AS=1.7e-12 PD=3.7e-06 PS=3.7e-06 NRD=0.2125 NRS=0.2125 $X=196500 $Y=15250 $D=37
M197 31 13 29 GNDA nmos4 L=2e-05 W=2e-06 AD=1.7e-12 AS=1.7e-12 PD=3.7e-06 PS=3.7e-06 NRD=0.2125 NRS=0.2125 $X=196500 $Y=40050 $D=37
M198 57 13 56 GNDA nmos4 L=2e-05 W=2e-06 AD=1.7e-12 AS=1.7e-12 PD=3.7e-06 PS=3.7e-06 NRD=0.2125 NRS=0.2125 $X=196500 $Y=64850 $D=37
M199 30 13 31 GNDA nmos4 L=2e-05 W=2e-06 AD=1.7e-12 AS=1.7e-12 PD=3.7e-06 PS=3.7e-06 NRD=0.2125 NRS=0.2125 $X=196500 $Y=89650 $D=37
M200 12 13 30 GNDA nmos4 L=2e-05 W=2e-06 AD=1.7e-12 AS=1.7e-12 PD=3.7e-06 PS=3.7e-06 NRD=0.2125 NRS=0.2125 $X=196500 $Y=114450 $D=37
M201 29 13 GNDA GNDA nmos4 L=2e-05 W=2e-06 AD=1.7e-12 AS=1.7e-12 PD=3.7e-06 PS=3.7e-06 NRD=0.2125 NRS=0.2125 $X=199750 $Y=15250 $D=37
M202 31 13 29 GNDA nmos4 L=2e-05 W=2e-06 AD=1.7e-12 AS=1.7e-12 PD=3.7e-06 PS=3.7e-06 NRD=0.2125 NRS=0.2125 $X=199750 $Y=40050 $D=37
M203 OUT 13 57 GNDA nmos4 L=2e-05 W=2e-06 AD=1.7e-12 AS=1.7e-12 PD=3.7e-06 PS=3.7e-06 NRD=0.2125 NRS=0.2125 $X=199750 $Y=64850 $D=37
M204 30 13 31 GNDA nmos4 L=2e-05 W=2e-06 AD=1.7e-12 AS=1.7e-12 PD=3.7e-06 PS=3.7e-06 NRD=0.2125 NRS=0.2125 $X=199750 $Y=89650 $D=37
M205 12 13 30 GNDA nmos4 L=2e-05 W=2e-06 AD=1.7e-12 AS=1.7e-12 PD=3.7e-06 PS=3.7e-06 NRD=0.2125 NRS=0.2125 $X=199750 $Y=114450 $D=37
M206 29 13 GNDA GNDA nmos4 L=2e-05 W=2e-06 AD=1.7e-12 AS=1.7e-12 PD=3.7e-06 PS=3.7e-06 NRD=0.2125 NRS=0.2125 $X=203000 $Y=15250 $D=37
M207 31 13 29 GNDA nmos4 L=2e-05 W=2e-06 AD=1.7e-12 AS=1.7e-12 PD=3.7e-06 PS=3.7e-06 NRD=0.2125 NRS=0.2125 $X=203000 $Y=40050 $D=37
M208 30 13 31 GNDA nmos4 L=2e-05 W=2e-06 AD=1.7e-12 AS=1.7e-12 PD=3.7e-06 PS=3.7e-06 NRD=0.2125 NRS=0.2125 $X=203000 $Y=89650 $D=37
M209 12 13 30 GNDA nmos4 L=2e-05 W=2e-06 AD=1.7e-12 AS=1.7e-12 PD=3.7e-06 PS=3.7e-06 NRD=0.2125 NRS=0.2125 $X=203000 $Y=114450 $D=37
M210 29 13 GNDA GNDA nmos4 L=2e-05 W=2e-06 AD=1.7e-12 AS=1.7e-12 PD=3.7e-06 PS=3.7e-06 NRD=0.2125 NRS=0.2125 $X=206250 $Y=15250 $D=37
M211 31 13 29 GNDA nmos4 L=2e-05 W=2e-06 AD=1.7e-12 AS=1.7e-12 PD=3.7e-06 PS=3.7e-06 NRD=0.2125 NRS=0.2125 $X=206250 $Y=40050 $D=37
M212 30 13 31 GNDA nmos4 L=2e-05 W=2e-06 AD=1.7e-12 AS=1.7e-12 PD=3.7e-06 PS=3.7e-06 NRD=0.2125 NRS=0.2125 $X=206250 $Y=89650 $D=37
M213 12 13 30 GNDA nmos4 L=2e-05 W=2e-06 AD=1.7e-12 AS=1.7e-12 PD=3.7e-06 PS=3.7e-06 NRD=0.2125 NRS=0.2125 $X=206250 $Y=114450 $D=37
M214 29 13 GNDA GNDA nmos4 L=2e-05 W=2e-06 AD=1.7e-12 AS=1.7e-12 PD=3.7e-06 PS=3.7e-06 NRD=0.2125 NRS=0.2125 $X=209500 $Y=15250 $D=37
M215 31 13 29 GNDA nmos4 L=2e-05 W=2e-06 AD=1.7e-12 AS=1.7e-12 PD=3.7e-06 PS=3.7e-06 NRD=0.2125 NRS=0.2125 $X=209500 $Y=40050 $D=37
M216 30 13 31 GNDA nmos4 L=2e-05 W=2e-06 AD=1.7e-12 AS=1.7e-12 PD=3.7e-06 PS=3.7e-06 NRD=0.2125 NRS=0.2125 $X=209500 $Y=89650 $D=37
M217 12 13 30 GNDA nmos4 L=2e-05 W=2e-06 AD=1.7e-12 AS=1.7e-12 PD=3.7e-06 PS=3.7e-06 NRD=0.2125 NRS=0.2125 $X=209500 $Y=114450 $D=37
M218 29 13 GNDA GNDA nmos4 L=2e-05 W=2e-06 AD=1.7e-12 AS=1.7e-12 PD=3.7e-06 PS=3.7e-06 NRD=0.2125 NRS=0.2125 $X=212750 $Y=15250 $D=37
M219 31 13 29 GNDA nmos4 L=2e-05 W=2e-06 AD=1.7e-12 AS=1.7e-12 PD=3.7e-06 PS=3.7e-06 NRD=0.2125 NRS=0.2125 $X=212750 $Y=40050 $D=37
M220 30 13 31 GNDA nmos4 L=2e-05 W=2e-06 AD=1.7e-12 AS=1.7e-12 PD=3.7e-06 PS=3.7e-06 NRD=0.2125 NRS=0.2125 $X=212750 $Y=89650 $D=37
M221 12 13 30 GNDA nmos4 L=2e-05 W=2e-06 AD=1.7e-12 AS=1.7e-12 PD=3.7e-06 PS=3.7e-06 NRD=0.2125 NRS=0.2125 $X=212750 $Y=114450 $D=37
M222 29 13 GNDA GNDA nmos4 L=2e-05 W=2e-06 AD=1.7e-12 AS=1.7e-12 PD=3.7e-06 PS=3.7e-06 NRD=0.2125 NRS=0.2125 $X=216000 $Y=15250 $D=37
M223 31 13 29 GNDA nmos4 L=2e-05 W=2e-06 AD=1.7e-12 AS=1.7e-12 PD=3.7e-06 PS=3.7e-06 NRD=0.2125 NRS=0.2125 $X=216000 $Y=40050 $D=37
M224 30 13 31 GNDA nmos4 L=2e-05 W=2e-06 AD=1.7e-12 AS=1.7e-12 PD=3.7e-06 PS=3.7e-06 NRD=0.2125 NRS=0.2125 $X=216000 $Y=89650 $D=37
M225 12 13 30 GNDA nmos4 L=2e-05 W=2e-06 AD=1.7e-12 AS=1.7e-12 PD=3.7e-06 PS=3.7e-06 NRD=0.2125 NRS=0.2125 $X=216000 $Y=114450 $D=37
M226 29 13 GNDA GNDA nmos4 L=2e-05 W=2e-06 AD=1.7e-12 AS=1.7e-12 PD=3.7e-06 PS=3.7e-06 NRD=0.2125 NRS=0.2125 $X=219250 $Y=15250 $D=37
M227 31 13 29 GNDA nmos4 L=2e-05 W=2e-06 AD=1.7e-12 AS=1.7e-12 PD=3.7e-06 PS=3.7e-06 NRD=0.2125 NRS=0.2125 $X=219250 $Y=40050 $D=37
M228 30 13 31 GNDA nmos4 L=2e-05 W=2e-06 AD=1.7e-12 AS=1.7e-12 PD=3.7e-06 PS=3.7e-06 NRD=0.2125 NRS=0.2125 $X=219250 $Y=89650 $D=37
M229 12 13 30 GNDA nmos4 L=2e-05 W=2e-06 AD=1.7e-12 AS=1.7e-12 PD=3.7e-06 PS=3.7e-06 NRD=0.2125 NRS=0.2125 $X=219250 $Y=114450 $D=37
M230 29 13 GNDA GNDA nmos4 L=2e-05 W=2e-06 AD=1.7e-12 AS=1.7e-12 PD=3.7e-06 PS=3.7e-06 NRD=0.2125 NRS=0.2125 $X=222500 $Y=15250 $D=37
M231 31 13 29 GNDA nmos4 L=2e-05 W=2e-06 AD=1.7e-12 AS=1.7e-12 PD=3.7e-06 PS=3.7e-06 NRD=0.2125 NRS=0.2125 $X=222500 $Y=40050 $D=37
M232 30 13 31 GNDA nmos4 L=2e-05 W=2e-06 AD=1.7e-12 AS=1.7e-12 PD=3.7e-06 PS=3.7e-06 NRD=0.2125 NRS=0.2125 $X=222500 $Y=89650 $D=37
M233 12 13 30 GNDA nmos4 L=2e-05 W=2e-06 AD=1.7e-12 AS=1.7e-12 PD=3.7e-06 PS=3.7e-06 NRD=0.2125 NRS=0.2125 $X=222500 $Y=114450 $D=37
M234 29 13 GNDA GNDA nmos4 L=2e-05 W=2e-06 AD=1.7e-12 AS=1.7e-12 PD=3.7e-06 PS=3.7e-06 NRD=0.2125 NRS=0.2125 $X=225750 $Y=15250 $D=37
M235 31 13 29 GNDA nmos4 L=2e-05 W=2e-06 AD=1.7e-12 AS=1.7e-12 PD=3.7e-06 PS=3.7e-06 NRD=0.2125 NRS=0.2125 $X=225750 $Y=40050 $D=37
M236 30 13 31 GNDA nmos4 L=2e-05 W=2e-06 AD=1.7e-12 AS=1.7e-12 PD=3.7e-06 PS=3.7e-06 NRD=0.2125 NRS=0.2125 $X=225750 $Y=89650 $D=37
M237 12 13 30 GNDA nmos4 L=2e-05 W=2e-06 AD=1.7e-12 AS=1.7e-12 PD=3.7e-06 PS=3.7e-06 NRD=0.2125 NRS=0.2125 $X=225750 $Y=114450 $D=37
M238 29 13 GNDA GNDA nmos4 L=2e-05 W=2e-06 AD=1.7e-12 AS=1.7e-12 PD=3.7e-06 PS=3.7e-06 NRD=0.2125 NRS=0.2125 $X=229000 $Y=15250 $D=37
M239 31 13 29 GNDA nmos4 L=2e-05 W=2e-06 AD=1.7e-12 AS=1.7e-12 PD=3.7e-06 PS=3.7e-06 NRD=0.2125 NRS=0.2125 $X=229000 $Y=40050 $D=37
M240 30 13 31 GNDA nmos4 L=2e-05 W=2e-06 AD=1.7e-12 AS=1.7e-12 PD=3.7e-06 PS=3.7e-06 NRD=0.2125 NRS=0.2125 $X=229000 $Y=89650 $D=37
M241 12 13 30 GNDA nmos4 L=2e-05 W=2e-06 AD=1.7e-12 AS=1.7e-12 PD=3.7e-06 PS=3.7e-06 NRD=0.2125 NRS=0.2125 $X=229000 $Y=114450 $D=37
M242 29 13 GNDA GNDA nmos4 L=2e-05 W=2e-06 AD=1.7e-12 AS=1.7e-12 PD=3.7e-06 PS=3.7e-06 NRD=0.2125 NRS=0.2125 $X=232250 $Y=15250 $D=37
M243 31 13 29 GNDA nmos4 L=2e-05 W=2e-06 AD=1.7e-12 AS=1.7e-12 PD=3.7e-06 PS=3.7e-06 NRD=0.2125 NRS=0.2125 $X=232250 $Y=40050 $D=37
M244 30 13 31 GNDA nmos4 L=2e-05 W=2e-06 AD=1.7e-12 AS=1.7e-12 PD=3.7e-06 PS=3.7e-06 NRD=0.2125 NRS=0.2125 $X=232250 $Y=89650 $D=37
M245 12 13 30 GNDA nmos4 L=2e-05 W=2e-06 AD=1.7e-12 AS=1.7e-12 PD=3.7e-06 PS=3.7e-06 NRD=0.2125 NRS=0.2125 $X=232250 $Y=114450 $D=37
M246 29 13 GNDA GNDA nmos4 L=2e-05 W=2e-06 AD=1.7e-12 AS=1.7e-12 PD=3.7e-06 PS=3.7e-06 NRD=0.2125 NRS=0.2125 $X=235500 $Y=15250 $D=37
M247 31 13 29 GNDA nmos4 L=2e-05 W=2e-06 AD=1.7e-12 AS=1.7e-12 PD=3.7e-06 PS=3.7e-06 NRD=0.2125 NRS=0.2125 $X=235500 $Y=40050 $D=37
M248 30 13 31 GNDA nmos4 L=2e-05 W=2e-06 AD=1.7e-12 AS=1.7e-12 PD=3.7e-06 PS=3.7e-06 NRD=0.2125 NRS=0.2125 $X=235500 $Y=89650 $D=37
M249 12 13 30 GNDA nmos4 L=2e-05 W=2e-06 AD=1.7e-12 AS=1.7e-12 PD=3.7e-06 PS=3.7e-06 NRD=0.2125 NRS=0.2125 $X=235500 $Y=114450 $D=37
M250 29 13 GNDA GNDA nmos4 L=2e-05 W=2e-06 AD=1.7e-12 AS=1.7e-12 PD=3.7e-06 PS=3.7e-06 NRD=0.2125 NRS=0.2125 $X=238750 $Y=15250 $D=37
M251 31 13 29 GNDA nmos4 L=2e-05 W=2e-06 AD=1.7e-12 AS=1.7e-12 PD=3.7e-06 PS=3.7e-06 NRD=0.2125 NRS=0.2125 $X=238750 $Y=40050 $D=37
M252 30 13 31 GNDA nmos4 L=2e-05 W=2e-06 AD=1.7e-12 AS=1.7e-12 PD=3.7e-06 PS=3.7e-06 NRD=0.2125 NRS=0.2125 $X=238750 $Y=89650 $D=37
M253 12 13 30 GNDA nmos4 L=2e-05 W=2e-06 AD=1.7e-12 AS=1.7e-12 PD=3.7e-06 PS=3.7e-06 NRD=0.2125 NRS=0.2125 $X=238750 $Y=114450 $D=37
M254 11 24 VDDA VDDA pmos4 L=5e-06 W=6e-06 AD=5.1e-12 AS=5.1e-12 PD=7.7e-06 PS=7.7e-06 NRD=0.0708333 NRS=0.0708333 $X=20775 $Y=175900 $D=41
M255 12 24 VDDA VDDA pmos4 L=5e-06 W=6e-06 AD=5.1e-12 AS=5.1e-12 PD=7.7e-06 PS=7.7e-06 NRD=0.0708333 NRS=0.0708333 $X=20775 $Y=186200 $D=41
M256 11 24 VDDA VDDA pmos4 L=5e-06 W=6e-06 AD=5.1e-12 AS=5.1e-12 PD=7.7e-06 PS=7.7e-06 NRD=0.0708333 NRS=0.0708333 $X=49975 $Y=175900 $D=41
M257 12 24 VDDA VDDA pmos4 L=5e-06 W=6e-06 AD=5.1e-12 AS=5.1e-12 PD=7.7e-06 PS=7.7e-06 NRD=0.0708333 NRS=0.0708333 $X=49975 $Y=186200 $D=41
M258 12 24 VDDA VDDA pmos4 L=5e-06 W=6e-06 AD=5.1e-12 AS=5.1e-12 PD=7.7e-06 PS=7.7e-06 NRD=0.0708333 NRS=0.0708333 $X=79175 $Y=175900 $D=41
M259 11 24 VDDA VDDA pmos4 L=5e-06 W=6e-06 AD=5.1e-12 AS=5.1e-12 PD=7.7e-06 PS=7.7e-06 NRD=0.0708333 NRS=0.0708333 $X=79175 $Y=186200 $D=41
M260 12 24 VDDA VDDA pmos4 L=5e-06 W=6e-06 AD=5.1e-12 AS=5.1e-12 PD=7.7e-06 PS=7.7e-06 NRD=0.0708333 NRS=0.0708333 $X=93775 $Y=175900 $D=41
M261 11 24 VDDA VDDA pmos4 L=5e-06 W=6e-06 AD=5.1e-12 AS=5.1e-12 PD=7.7e-06 PS=7.7e-06 NRD=0.0708333 NRS=0.0708333 $X=93775 $Y=186200 $D=41
M262 16 10 VDDA VDDA pmos4 L=5e-06 W=5e-06 AD=4.25e-12 AS=4.25e-12 PD=6.7e-06 PS=6.7e-06 NRD=0.085 NRS=0.085 $X=238675 $Y=180200 $D=41
M263 OUT 10 15 VDDA pmos4 L=5e-06 W=5e-06 AD=4.25e-12 AS=4.25e-12 PD=6.7e-06 PS=6.7e-06 NRD=0.085 NRS=0.085 $X=238675 $Y=190600 $D=41
M264 15 10 VDDA VDDA pmos4 L=5e-06 W=5e-06 AD=4.25e-12 AS=4.25e-12 PD=6.7e-06 PS=6.7e-06 NRD=0.085 NRS=0.085 $X=245975 $Y=180200 $D=41
M265 10 10 16 VDDA pmos4 L=5e-06 W=5e-06 AD=4.25e-12 AS=4.25e-12 PD=6.7e-06 PS=6.7e-06 NRD=0.085 NRS=0.085 $X=245975 $Y=190600 $D=41
C266 GNDA VDDA $[cpolya] $A=750 $P=110 $X=273650 $Y=161350 $D=58
X267 GNDA ICV_68 $T=46300 16200 0 0 $X=45900 $Y=15950
X268 GNDA ICV_68 $T=46300 84700 0 0 $X=45900 $Y=84450
X269 GNDA ICV_70 $T=7300 16200 0 0 $X=6900 $Y=15950
X270 GNDA ICV_70 $T=7300 84700 0 0 $X=6900 $Y=84450
X271 GNDA ICV_70 $T=20300 16200 0 0 $X=19900 $Y=15950
X272 GNDA ICV_70 $T=20300 84700 0 0 $X=19900 $Y=84450
X273 GNDA ICV_70 $T=33300 16200 0 0 $X=32900 $Y=15950
X274 GNDA ICV_70 $T=33300 84700 0 0 $X=32900 $Y=84450
X283 23 33 13 33 13 37 33 37 33 42 37 GNDA ICV_72 $T=7300 25100 0 0 $X=6900 $Y=24850
X284 23 34 14 34 14 38 34 38 34 43 38 GNDA ICV_72 $T=7300 40000 0 0 $X=6900 $Y=39750
X285 23 GNDA 32 32 39 32 39 39 40 40 23 GNDA ICV_72 $T=7300 54900 0 0 $X=6900 $Y=54650
X286 23 35 25 35 25 36 35 36 35 41 36 GNDA ICV_72 $T=7300 69800 0 0 $X=6900 $Y=69550
X287 GNDA BIAS cpolyc_CDNS_78073660103100 $T=10250 157150 0 270 $X=8900 $Y=123000
X288 23 BIAS BIAS GNDA nmos4_CDNS_7807366010396 $T=22900 102700 0 90 $X=11950 $Y=102000
X289 25 24 BIAS GNDA nmos4_CDNS_7807366010396 $T=34200 102700 0 90 $X=23250 $Y=102000
X292 VDDA 11 24 ICV_66 $T=78325 181900 0 270 $X=77125 $Y=174700
X293 VDDA 12 24 ICV_66 $T=78325 192200 0 270 $X=77125 $Y=185000
X294 VDDA 12 11 12 24 ICV_67 $T=19925 181900 0 270 $X=18725 $Y=174700
X295 VDDA 11 12 11 24 ICV_67 $T=19925 192200 0 270 $X=18725 $Y=185000
X296 VDDA 24 12 11 24 ICV_67 $T=49125 181900 0 270 $X=47925 $Y=174700
X297 VDDA 24 11 12 24 ICV_67 $T=49125 192200 0 270 $X=47925 $Y=185000
X338 12 13 INP pmos4_CDNS_78073660103103 $T=164025 157775 0 90 $X=135125 $Y=156575
X339 11 14 INN pmos4_CDNS_78073660103103 $T=164025 193925 1 270 $X=135125 $Y=177725
X340 11 14 INN pmos4_CDNS_78073660103103 $T=200125 157775 0 90 $X=171225 $Y=156575
X341 12 13 INP pmos4_CDNS_78073660103103 $T=200125 193925 1 270 $X=171225 $Y=177725
X366 GNDA OUT cpolyc_CDNS_7807366010398 $T=310100 23300 0 0 $X=308750 $Y=21950
X367 GNDA OUT cpolyc_CDNS_7807366010398 $T=310100 79000 0 0 $X=308750 $Y=77650
X368 GNDA OUT cpolyc_CDNS_7807366010398 $T=310100 134700 0 0 $X=308750 $Y=133350
X369 GNDA 18 cpolyc_CDNS_7807366010398 $T=388600 23400 0 0 $X=387250 $Y=22050
X370 GNDA 18 cpolyc_CDNS_7807366010398 $T=388600 79100 0 0 $X=387250 $Y=77750
X371 GNDA 18 cpolyc_CDNS_7807366010398 $T=388600 134700 0 0 $X=387250 $Y=133350
X374 S<0> VDDA GNDA 17 INVX1 $T=338900 194150 0 0 $X=338050 $Y=192800
X375 S<2> VDDA GNDA 21 INVX1 $T=341700 194150 0 0 $X=340850 $Y=192800
X376 S<1> VDDA GNDA 19 INVX1 $T=344500 194150 0 0 $X=343650 $Y=192800
X377 18 OUT 17 VDDA pmos4_CDNS_7807366010394 $T=357100 202750 0 270 $X=355900 $Y=199550
X378 OUT 20 19 VDDA pmos4_CDNS_7807366010394 $T=370600 200750 0 90 $X=366700 $Y=199550
X379 OUT 22 21 VDDA pmos4_CDNS_7807366010394 $T=382450 200750 0 90 $X=378550 $Y=199550
X380 OUT 18 S<0> GNDA nmos4_CDNS_7807366010397 $T=359800 194450 0 90 $X=356850 $Y=194050
X381 20 OUT S<1> GNDA nmos4_CDNS_7807366010397 $T=367900 196450 0 270 $X=367650 $Y=194050
X382 22 OUT S<2> GNDA nmos4_CDNS_7807366010397 $T=379750 196450 0 270 $X=379500 $Y=194050
X383 GNDA 20 ICV_111 $T=467100 23300 0 0 $X=465750 $Y=21950
X384 GNDA 20 ICV_111 $T=467100 79000 0 0 $X=465750 $Y=77650
X385 GNDA 20 ICV_111 $T=467100 134700 0 0 $X=465750 $Y=133350
X386 GNDA 22 ICV_111 $T=622100 23300 0 0 $X=620750 $Y=21950
X387 GNDA 22 ICV_111 $T=622100 79000 0 0 $X=620750 $Y=77650
X388 GNDA 22 ICV_111 $T=622100 134700 0 0 $X=620750 $Y=133350
X389 GNDA 22 ICV_111 $T=775100 23300 0 0 $X=773750 $Y=21950
X390 GNDA 22 ICV_111 $T=775100 79000 0 0 $X=773750 $Y=77650
X391 GNDA 22 ICV_111 $T=775100 134700 0 0 $X=773750 $Y=133350
.ENDS
***************************************
.SUBCKT nmos4_CDNS_7807366010386 1 2 3 4
** N=4 EP=4 IP=0 FDC=4
M0 2 3 1 4 nmos4 L=1e-06 W=5e-06 AD=2.5e-12 AS=4.25e-12 PD=1e-06 PS=6.7e-06 NRD=0.085 NRS=0.085 $X=0 $Y=850 $D=37
M1 1 3 2 4 nmos4 L=1e-06 W=5e-06 AD=2.5e-12 AS=2.5e-12 PD=1e-06 PS=1e-06 NRD=0.085 NRS=0.085 $X=0 $Y=2850 $D=37
M2 2 3 1 4 nmos4 L=1e-06 W=5e-06 AD=2.5e-12 AS=2.5e-12 PD=1e-06 PS=1e-06 NRD=0.085 NRS=0.085 $X=0 $Y=4850 $D=37
M3 1 3 2 4 nmos4 L=1e-06 W=5e-06 AD=4.25e-12 AS=2.5e-12 PD=6.7e-06 PS=1e-06 NRD=0.085 NRS=0.085 $X=0 $Y=6850 $D=37
.ENDS
***************************************
.SUBCKT nmos4_CDNS_7807366010387
** N=3 EP=0 IP=0 FDC=0
.ENDS
***************************************
.SUBCKT ICV_83 1 2 4
** N=5 EP=3 IP=6 FDC=1
M0 2 4 1 1 nmos4 L=1e-05 W=8e-06 AD=6.8e-12 AS=6.8e-12 PD=9.7e-06 PS=9.7e-06 NRD=0.053125 NRS=0.053125 $X=0 $Y=-11950 $D=37
.ENDS
***************************************
.SUBCKT ICV_84 1 2 3 4 6
** N=7 EP=5 IP=10 FDC=3
M0 3 6 1 1 nmos4 L=1e-05 W=8e-06 AD=6.8e-12 AS=6.8e-12 PD=9.7e-06 PS=9.7e-06 NRD=0.053125 NRS=0.053125 $X=0 $Y=-24750 $D=37
X1 1 2 6 ICV_83 $T=0 -25600 0 0 $X=-400 $Y=-38650
X2 1 4 6 ICV_83 $T=0 0 0 0 $X=-400 $Y=-13050
.ENDS
***************************************
.SUBCKT P1_C_CDNS_78073660103155
** N=2 EP=0 IP=0 FDC=0
.ENDS
***************************************
.SUBCKT PD_C_CDNS_78073660103305
** N=1 EP=0 IP=0 FDC=0
.ENDS
***************************************
.SUBCKT P1_C_CDNS_78073660103109
** N=2 EP=0 IP=0 FDC=0
.ENDS
***************************************
.SUBCKT pmos4_CDNS_7807366010388
** N=4 EP=0 IP=0 FDC=0
.ENDS
***************************************
.SUBCKT ICV_82 1 2 4
** N=6 EP=3 IP=8 FDC=1
M0 2 4 1 1 pmos4 L=3e-06 W=5e-06 AD=4.25e-12 AS=4.25e-12 PD=6.7e-06 PS=6.7e-06 NRD=0.085 NRS=0.085 $X=0 $Y=-4450 $D=41
.ENDS
***************************************
.SUBCKT P1_C_CDNS_78073660103304
** N=2 EP=0 IP=0 FDC=0
.ENDS
***************************************
.SUBCKT pmos4_CDNS_7807366010373 1 2 3 5
** N=5 EP=4 IP=0 FDC=2
M0 2 3 1 5 pmos4 L=1e-06 W=5e-06 AD=2.5e-12 AS=4.25e-12 PD=1e-06 PS=6.7e-06 NRD=0.085 NRS=0.085 $X=0 $Y=850 $D=41
M1 1 3 2 5 pmos4 L=1e-06 W=5e-06 AD=4.25e-12 AS=2.5e-12 PD=6.7e-06 PS=1e-06 NRD=0.085 NRS=0.085 $X=0 $Y=2850 $D=41
.ENDS
***************************************
.SUBCKT nmos4_CDNS_7807366010385
** N=4 EP=0 IP=0 FDC=0
.ENDS
***************************************
.SUBCKT ICV_80
** N=7 EP=0 IP=8 FDC=0
.ENDS
***************************************
.SUBCKT ICV_81 1 2 3 6 7 9
** N=9 EP=6 IP=14 FDC=3
M0 2 6 1 9 nmos4 L=3.5e-07 W=5e-06 AD=4.25e-12 AS=4.25e-12 PD=6.7e-06 PS=6.7e-06 NRD=0.085 NRS=0.085 $X=0 $Y=-7100 $D=37
M1 2 7 3 9 nmos4 L=3.5e-07 W=5e-06 AD=4.25e-12 AS=4.25e-12 PD=6.7e-06 PS=6.7e-06 NRD=0.085 NRS=0.085 $X=0 $Y=-4450 $D=37
M2 2 6 1 9 nmos4 L=3.5e-07 W=5e-06 AD=4.25e-12 AS=4.25e-12 PD=6.7e-06 PS=6.7e-06 NRD=0.085 NRS=0.085 $X=0 $Y=-1800 $D=37
.ENDS
***************************************
.SUBCKT nmos4_CDNS_7807366010378 1 2 3 4
** N=4 EP=4 IP=0 FDC=2
M0 2 3 1 4 nmos4 L=1e-06 W=1e-05 AD=5e-12 AS=8.5e-12 PD=1e-06 PS=1.17e-05 NRD=0.0425 NRS=0.0425 $X=0 $Y=850 $D=37
M1 1 3 2 4 nmos4 L=1e-06 W=1e-05 AD=8.5e-12 AS=5e-12 PD=1.17e-05 PS=1e-06 NRD=0.0425 NRS=0.0425 $X=0 $Y=2850 $D=37
.ENDS
***************************************
.SUBCKT pmos4_CDNS_7807366010381
** N=4 EP=0 IP=0 FDC=0
.ENDS
***************************************
.SUBCKT ICV_78
** N=6 EP=0 IP=8 FDC=0
.ENDS
***************************************
.SUBCKT ICV_79 1 2 3 5 6
** N=8 EP=5 IP=12 FDC=3
M0 2 5 1 1 pmos4 L=3.5e-07 W=5e-06 AD=4.25e-12 AS=4.25e-12 PD=6.7e-06 PS=6.7e-06 NRD=0.085 NRS=0.085 $X=0 $Y=-7100 $D=41
M1 2 5 1 1 pmos4 L=3.5e-07 W=5e-06 AD=4.25e-12 AS=4.25e-12 PD=6.7e-06 PS=6.7e-06 NRD=0.085 NRS=0.085 $X=0 $Y=-4450 $D=41
M2 3 6 1 1 pmos4 L=3.5e-07 W=5e-06 AD=4.25e-12 AS=4.25e-12 PD=6.7e-06 PS=6.7e-06 NRD=0.085 NRS=0.085 $X=0 $Y=-1800 $D=41
.ENDS
***************************************
.SUBCKT nmos4_CDNS_7807366010377 1 2 3
** N=3 EP=3 IP=0 FDC=1
M0 2 3 1 1 nmos4 L=4e-06 W=4e-06 AD=3.4e-12 AS=3.4e-12 PD=5.7e-06 PS=5.7e-06 NRD=0.10625 NRS=0.10625 $X=0 $Y=850 $D=37
.ENDS
***************************************
.SUBCKT P1_C_CDNS_7807366010396
** N=2 EP=0 IP=0 FDC=0
.ENDS
***************************************
.SUBCKT pmos4_CDNS_7807366010379
** N=4 EP=0 IP=0 FDC=0
.ENDS
***************************************
.SUBCKT ICV_75 1 3 5
** N=6 EP=3 IP=8 FDC=1
M0 3 5 1 1 pmos4 L=3e-06 W=1e-05 AD=8.5e-12 AS=8.5e-12 PD=1.17e-05 PS=1.17e-05 NRD=0.0425 NRS=0.0425 $X=0 $Y=6150 $D=41
.ENDS
***************************************
.SUBCKT ICV_76 1 3 4 5 7
** N=8 EP=5 IP=12 FDC=3
M0 4 7 1 1 pmos4 L=3e-06 W=1e-05 AD=8.5e-12 AS=8.5e-12 PD=1.17e-05 PS=1.17e-05 NRD=0.0425 NRS=0.0425 $X=0 $Y=11450 $D=41
X1 1 3 7 ICV_75 $T=0 0 0 0 $X=-1200 $Y=-1200
X2 1 5 7 ICV_75 $T=0 10600 0 0 $X=-1200 $Y=9400
.ENDS
***************************************
.SUBCKT nmos4_CDNS_7807366010380
** N=3 EP=0 IP=0 FDC=0
.ENDS
***************************************
.SUBCKT ICV_73 1 3 5
** N=5 EP=3 IP=6 FDC=1
M0 3 5 1 1 nmos4 L=1e-06 W=5e-06 AD=4.25e-12 AS=4.25e-12 PD=6.7e-06 PS=6.7e-06 NRD=0.085 NRS=0.085 $X=0 $Y=4150 $D=37
.ENDS
***************************************
.SUBCKT ICV_74 1 3 4 6
** N=6 EP=4 IP=10 FDC=3
M0 4 6 1 1 nmos4 L=1e-06 W=5e-06 AD=4.25e-12 AS=4.25e-12 PD=6.7e-06 PS=6.7e-06 NRD=0.085 NRS=0.085 $X=0 $Y=7450 $D=37
X1 1 3 6 ICV_73 $T=0 0 0 0 $X=-400 $Y=-250
X2 1 3 6 ICV_73 $T=0 6600 0 0 $X=-400 $Y=6350
.ENDS
***************************************
.SUBCKT ICV_77 1 2 3
** N=3 EP=3 IP=12 FDC=8
M0 1 1 1 1 nmos4 L=1e-06 W=5e-06 AD=4.25e-12 AS=4.25e-12 PD=6.7e-06 PS=6.7e-06 NRD=0.085 NRS=0.085 $X=0 $Y=850 $D=38
M1 2 3 1 1 nmos4 L=1e-06 W=5e-06 AD=4.25e-12 AS=4.25e-12 PD=6.7e-06 PS=6.7e-06 NRD=0.085 NRS=0.085 $X=0 $Y=14050 $D=37
X2 1 2 2 3 ICV_74 $T=0 0 0 0 $X=-400 $Y=-250
X3 1 2 3 3 ICV_74 $T=0 13200 0 0 $X=-400 $Y=12950
.ENDS
***************************************
.SUBCKT cmfb_opamp1_fc 1 2 OUT GNDA VDDA INP INN BIAS
** N=12 EP=8 IP=190 FDC=90
D0 GNDA 10 p_nwd AREA=2103.7 PJ=186.2 $X=7125 $Y=53475 $D=87
D1 GNDA VDDA p_nwd AREA=5361.48 PJ=295.8 $X=65050 $Y=64650 $D=87
M2 GNDA GNDA GNDA GNDA nmos4 L=1e-06 W=5e-06 AD=4.25e-12 AS=4.25e-12 PD=6.7e-06 PS=6.7e-06 NRD=0.085 NRS=0.085 $X=134675 $Y=32950 $D=38
M3 GNDA GNDA GNDA GNDA nmos4 L=1e-06 W=5e-06 AD=4.25e-12 AS=4.25e-12 PD=6.7e-06 PS=6.7e-06 NRD=0.085 NRS=0.085 $X=134675 $Y=41450 $D=38
M4 9 9 GNDA GNDA nmos4 L=1e-06 W=5e-06 AD=2.5e-12 AS=4.25e-12 PD=1e-06 PS=6.7e-06 NRD=0.085 NRS=0.085 $X=52300 $Y=29850 $D=37
M5 GNDA 9 9 GNDA nmos4 L=1e-06 W=5e-06 AD=4.25e-12 AS=2.5e-12 PD=6.7e-06 PS=1e-06 NRD=0.085 NRS=0.085 $X=54300 $Y=29850 $D=37
M6 OUT 1 GNDA GNDA nmos4 L=1e-06 W=5e-06 AD=4.25e-12 AS=4.25e-12 PD=6.7e-06 PS=6.7e-06 NRD=0.085 NRS=0.085 $X=121475 $Y=32950 $D=37
M7 OUT 1 GNDA GNDA nmos4 L=1e-06 W=5e-06 AD=4.25e-12 AS=4.25e-12 PD=6.7e-06 PS=6.7e-06 NRD=0.085 NRS=0.085 $X=121475 $Y=41450 $D=37
M8 10 10 10 10 pmos4 L=3.5e-07 W=5e-06 AD=4.25e-12 AS=4.25e-12 PD=6.7e-06 PS=6.7e-06 NRD=0.085 NRS=0.085 $X=22275 $Y=63775 $D=42
M9 10 10 10 10 pmos4 L=3.5e-07 W=5e-06 AD=4.25e-12 AS=4.25e-12 PD=6.7e-06 PS=6.7e-06 NRD=0.085 NRS=0.085 $X=22275 $Y=76775 $D=42
M10 10 10 10 10 pmos4 L=3.5e-07 W=5e-06 AD=4.25e-12 AS=4.25e-12 PD=6.7e-06 PS=6.7e-06 NRD=0.085 NRS=0.085 $X=46125 $Y=63775 $D=42
M11 10 10 10 10 pmos4 L=3.5e-07 W=5e-06 AD=4.25e-12 AS=4.25e-12 PD=6.7e-06 PS=6.7e-06 NRD=0.085 NRS=0.085 $X=46125 $Y=76775 $D=42
M12 VDDA VDDA VDDA VDDA pmos4 L=3e-06 W=1e-05 AD=8.5e-12 AS=8.5e-12 PD=1.17e-05 PS=1.17e-05 NRD=0.0425 NRS=0.0425 $X=132200 $Y=74950 $D=42
M13 VDDA VDDA VDDA VDDA pmos4 L=3e-06 W=1e-05 AD=8.5e-12 AS=8.5e-12 PD=1.17e-05 PS=1.17e-05 NRD=0.0425 NRS=0.0425 $X=132200 $Y=92950 $D=42
M14 10 INP 1 10 pmos4 L=3.5e-07 W=5e-06 AD=4.25e-12 AS=4.25e-12 PD=6.7e-06 PS=6.7e-06 NRD=0.085 NRS=0.085 $X=32875 $Y=63775 $D=41
M15 10 INN 9 10 pmos4 L=3.5e-07 W=5e-06 AD=4.25e-12 AS=4.25e-12 PD=6.7e-06 PS=6.7e-06 NRD=0.085 NRS=0.085 $X=32875 $Y=76775 $D=41
M16 10 INP 1 10 pmos4 L=3.5e-07 W=5e-06 AD=4.25e-12 AS=4.25e-12 PD=6.7e-06 PS=6.7e-06 NRD=0.085 NRS=0.085 $X=43475 $Y=63775 $D=41
M17 10 INN 9 10 pmos4 L=3.5e-07 W=5e-06 AD=4.25e-12 AS=4.25e-12 PD=6.7e-06 PS=6.7e-06 NRD=0.085 NRS=0.085 $X=43475 $Y=76775 $D=41
M18 OUT 2 VDDA VDDA pmos4 L=3e-06 W=1e-05 AD=8.5e-12 AS=8.5e-12 PD=1.17e-05 PS=1.17e-05 NRD=0.0425 NRS=0.0425 $X=79200 $Y=74950 $D=41
M19 OUT 2 VDDA VDDA pmos4 L=3e-06 W=1e-05 AD=8.5e-12 AS=8.5e-12 PD=1.17e-05 PS=1.17e-05 NRD=0.0425 NRS=0.0425 $X=79200 $Y=92950 $D=41
M20 OUT 2 VDDA VDDA pmos4 L=3e-06 W=1e-05 AD=8.5e-12 AS=8.5e-12 PD=1.17e-05 PS=1.17e-05 NRD=0.0425 NRS=0.0425 $X=79200 $Y=110950 $D=41
M21 OUT 2 VDDA VDDA pmos4 L=3e-06 W=1e-05 AD=8.5e-12 AS=8.5e-12 PD=1.17e-05 PS=1.17e-05 NRD=0.0425 NRS=0.0425 $X=100400 $Y=74950 $D=41
M22 10 2 VDDA VDDA pmos4 L=3e-06 W=1e-05 AD=8.5e-12 AS=8.5e-12 PD=1.17e-05 PS=1.17e-05 NRD=0.0425 NRS=0.0425 $X=100400 $Y=92950 $D=41
M23 OUT 2 VDDA VDDA pmos4 L=3e-06 W=1e-05 AD=8.5e-12 AS=8.5e-12 PD=1.17e-05 PS=1.17e-05 NRD=0.0425 NRS=0.0425 $X=100400 $Y=110950 $D=41
M24 OUT 2 VDDA VDDA pmos4 L=3e-06 W=1e-05 AD=8.5e-12 AS=8.5e-12 PD=1.17e-05 PS=1.17e-05 NRD=0.0425 NRS=0.0425 $X=121600 $Y=74950 $D=41
M25 OUT 2 VDDA VDDA pmos4 L=3e-06 W=1e-05 AD=8.5e-12 AS=8.5e-12 PD=1.17e-05 PS=1.17e-05 NRD=0.0425 NRS=0.0425 $X=121600 $Y=92950 $D=41
M26 OUT 2 VDDA VDDA pmos4 L=3e-06 W=1e-05 AD=8.5e-12 AS=8.5e-12 PD=1.17e-05 PS=1.17e-05 NRD=0.0425 NRS=0.0425 $X=121600 $Y=110950 $D=41
M27 OUT 2 VDDA VDDA pmos4 L=3e-06 W=1e-05 AD=8.5e-12 AS=8.5e-12 PD=1.17e-05 PS=1.17e-05 NRD=0.0425 NRS=0.0425 $X=132200 $Y=110950 $D=41
C28 2 VDDA $[cpolya] $A=1345.5 $P=149.7 $X=10650 $Y=95600 $D=58
X42 11 BIAS BIAS GNDA nmos4_CDNS_7807366010378 $T=18350 33400 0 90 $X=13400 $Y=32700
X43 12 2 BIAS GNDA nmos4_CDNS_7807366010378 $T=23650 33400 0 90 $X=18700 $Y=32700
X46 10 9 1 INN INP ICV_79 $T=23475 63775 0 90 $X=20225 $Y=62575
X47 10 1 9 INP INN ICV_79 $T=23475 76775 0 90 $X=20225 $Y=75575
X48 10 9 1 INN INP ICV_79 $T=34075 63775 0 90 $X=30825 $Y=62575
X49 10 1 9 INP INN ICV_79 $T=34075 76775 0 90 $X=30825 $Y=75575
X50 GNDA 11 11 nmos4_CDNS_7807366010377 $T=37400 29950 0 90 $X=31450 $Y=29550
X51 GNDA 12 11 nmos4_CDNS_7807366010377 $T=43700 29950 0 90 $X=37750 $Y=29550
X57 VDDA OUT 2 ICV_75 $T=120750 84950 0 270 $X=119550 $Y=73750
X58 VDDA OUT 2 ICV_75 $T=120750 102950 0 270 $X=119550 $Y=91750
X59 VDDA OUT 2 ICV_75 $T=120750 120950 0 270 $X=119550 $Y=109750
X60 VDDA OUT OUT OUT 2 ICV_76 $T=78350 84950 0 270 $X=77150 $Y=73750
X61 VDDA OUT OUT OUT 2 ICV_76 $T=78350 102950 0 270 $X=77150 $Y=91750
X62 VDDA OUT OUT OUT 2 ICV_76 $T=78350 120950 0 270 $X=77150 $Y=109750
X63 VDDA 10 OUT OUT 2 ICV_76 $T=99550 84950 0 270 $X=98350 $Y=73750
X64 VDDA 2 10 10 2 ICV_76 $T=99550 102950 0 270 $X=98350 $Y=91750
X65 VDDA 10 OUT OUT 2 ICV_76 $T=99550 120950 0 270 $X=98350 $Y=109750
X68 GNDA OUT OUT 1 ICV_74 $T=120625 37950 0 270 $X=120375 $Y=32550
X69 GNDA OUT OUT 1 ICV_74 $T=120625 46450 0 270 $X=120375 $Y=41050
X70 GNDA OUT 1 ICV_77 $T=94225 37950 0 270 $X=93975 $Y=32550
X71 GNDA OUT 1 ICV_77 $T=94225 46450 0 270 $X=93975 $Y=41050
.ENDS
***************************************
.SUBCKT rpolyhc_CDNS_7807366010384 1 2
** N=3 EP=2 IP=0 FDC=1
R0 1 2 L=0.00049995 W=8e-07 $[rpolyh] $X=-800 $Y=1550 $D=18
.ENDS
***************************************
.SUBCKT ND_C_CDNS_78073660103324
** N=2 EP=0 IP=0 FDC=0
.ENDS
***************************************
.SUBCKT rpolyhc_CDNS_7807366010393 1 2 3
** N=3 EP=3 IP=0 FDC=2
R0 1 2 L=0.00499975 W=8e-07 $[rpolyh] $X=-800 $Y=1550 $D=18
D1 3 3 p_nwd AREA=10336.4 PJ=480.7 $X=-6650 $Y=-5950 $D=87
.ENDS
***************************************
.SUBCKT fecg_cmfb2_fc CM VREF_CM EN_CMFB BIAS VDDA GNDA INP INN CMFB 10
** N=27 EP=10 IP=230 FDC=267
R0 18 CMFB L=0.00499765 W=8e-07 $[rpolyh] $X=259225 $Y=145800 $D=18
D1 GNDA VDDA p_nwd AREA=2047.5 PJ=184.2 $X=57475 $Y=165200 $D=87
D2 GNDA VDDA p_nwd AREA=850.2 PJ=117.4 $X=118200 $Y=170000 $D=87
D3 GNDA GNDA p_nwd AREA=13200.1 PJ=568 $X=206625 $Y=139700 $D=87
D4 GNDA VDDA p_nwd AREA=52.15 PJ=28.9 $X=455350 $Y=158300 $D=87
D5 GNDA VDDA p_nwd AREA=52.15 PJ=28.9 $X=455350 $Y=177025 $D=87
D6 GNDA VDDA p_nwd AREA=22.25 PJ=18.9 $X=457375 $Y=138350 $D=87
M7 GNDA GNDA GNDA GNDA nmos4 L=1e-05 W=8e-06 AD=6.8e-12 AS=6.8e-12 PD=9.7e-06 PS=9.7e-06 NRD=0.053125 NRS=0.053125 $X=28625 $Y=30100 $D=38
M8 GNDA GNDA GNDA GNDA nmos4 L=1e-05 W=8e-06 AD=6.8e-12 AS=6.8e-12 PD=9.7e-06 PS=9.7e-06 NRD=0.053125 NRS=0.053125 $X=28625 $Y=40800 $D=38
M9 GNDA GNDA GNDA GNDA nmos4 L=1e-05 W=8e-06 AD=6.8e-12 AS=6.8e-12 PD=9.7e-06 PS=9.7e-06 NRD=0.053125 NRS=0.053125 $X=131025 $Y=30100 $D=38
M10 GNDA GNDA GNDA GNDA nmos4 L=1e-05 W=8e-06 AD=6.8e-12 AS=6.8e-12 PD=9.7e-06 PS=9.7e-06 NRD=0.053125 NRS=0.053125 $X=131025 $Y=40800 $D=38
M11 GNDA GNDA GNDA GNDA nmos4 L=3.5e-07 W=5e-06 AD=4.25e-12 AS=4.25e-12 PD=6.7e-06 PS=6.7e-06 NRD=0.085 NRS=0.085 $X=162975 $Y=175750 $D=38
M12 GNDA GNDA GNDA GNDA nmos4 L=3.5e-07 W=5e-06 AD=4.25e-12 AS=4.25e-12 PD=6.7e-06 PS=6.7e-06 NRD=0.085 NRS=0.085 $X=162975 $Y=188050 $D=38
M13 GNDA GNDA GNDA GNDA nmos4 L=3.5e-07 W=5e-06 AD=4.25e-12 AS=4.25e-12 PD=6.7e-06 PS=6.7e-06 NRD=0.085 NRS=0.085 $X=186825 $Y=175750 $D=38
M14 GNDA GNDA GNDA GNDA nmos4 L=3.5e-07 W=5e-06 AD=4.25e-12 AS=4.25e-12 PD=6.7e-06 PS=6.7e-06 NRD=0.085 NRS=0.085 $X=186825 $Y=188050 $D=38
M15 GNDA 14 13 GNDA nmos4 L=1e-05 W=8e-06 AD=6.8e-12 AS=6.8e-12 PD=9.7e-06 PS=9.7e-06 NRD=0.053125 NRS=0.053125 $X=79825 $Y=30100 $D=37
M16 GNDA 14 12 GNDA nmos4 L=1e-05 W=8e-06 AD=6.8e-12 AS=6.8e-12 PD=9.7e-06 PS=9.7e-06 NRD=0.053125 NRS=0.053125 $X=79825 $Y=40800 $D=37
M17 13 INP VDDA GNDA nmos4 L=3.5e-07 W=5e-06 AD=4.25e-12 AS=4.25e-12 PD=6.7e-06 PS=6.7e-06 NRD=0.085 NRS=0.085 $X=173575 $Y=175750 $D=37
M18 12 INN VDDA GNDA nmos4 L=3.5e-07 W=5e-06 AD=4.25e-12 AS=4.25e-12 PD=6.7e-06 PS=6.7e-06 NRD=0.085 NRS=0.085 $X=173575 $Y=188050 $D=37
M19 12 INN VDDA GNDA nmos4 L=3.5e-07 W=5e-06 AD=4.25e-12 AS=4.25e-12 PD=6.7e-06 PS=6.7e-06 NRD=0.085 NRS=0.085 $X=184175 $Y=175750 $D=37
M20 13 INP VDDA GNDA nmos4 L=3.5e-07 W=5e-06 AD=4.25e-12 AS=4.25e-12 PD=6.7e-06 PS=6.7e-06 NRD=0.085 NRS=0.085 $X=184175 $Y=188050 $D=37
M21 20 EN_CMFB INP GNDA nmos4 L=3.5e-07 W=5e-06 AD=4.25e-12 AS=4.25e-12 PD=6.7e-06 PS=6.7e-06 NRD=0.085 NRS=0.085 $X=456550 $Y=173325 $D=37
M22 21 EN_CMFB INN GNDA nmos4 L=3.5e-07 W=5e-06 AD=4.25e-12 AS=4.25e-12 PD=6.7e-06 PS=6.7e-06 NRD=0.085 NRS=0.085 $X=456600 $Y=154600 $D=37
M23 VDDA VDDA VDDA VDDA pmos4 L=3e-06 W=5e-06 AD=4.25e-12 AS=4.25e-12 PD=6.7e-06 PS=6.7e-06 NRD=0.085 NRS=0.085 $X=72675 $Y=176550 $D=42
M24 VDDA VDDA VDDA VDDA pmos4 L=3e-06 W=5e-06 AD=4.25e-12 AS=4.25e-12 PD=6.7e-06 PS=6.7e-06 NRD=0.085 NRS=0.085 $X=72675 $Y=186350 $D=42
M25 VDDA VDDA VDDA VDDA pmos4 L=3e-06 W=5e-06 AD=4.25e-12 AS=4.25e-12 PD=6.7e-06 PS=6.7e-06 NRD=0.085 NRS=0.085 $X=93875 $Y=176550 $D=42
M26 VDDA VDDA VDDA VDDA pmos4 L=3e-06 W=5e-06 AD=4.25e-12 AS=4.25e-12 PD=6.7e-06 PS=6.7e-06 NRD=0.085 NRS=0.085 $X=93875 $Y=186350 $D=42
M27 VDDA 22 16 VDDA pmos4 L=3e-06 W=5e-06 AD=4.25e-12 AS=4.25e-12 PD=6.7e-06 PS=6.7e-06 NRD=0.085 NRS=0.085 $X=83275 $Y=176550 $D=41
M28 VDDA 22 16 VDDA pmos4 L=3e-06 W=5e-06 AD=4.25e-12 AS=4.25e-12 PD=6.7e-06 PS=6.7e-06 NRD=0.085 NRS=0.085 $X=83275 $Y=186350 $D=41
M29 INN 27 21 VDDA pmos4 L=3.5e-07 W=5e-06 AD=2.5e-12 AS=4.25e-12 PD=1e-06 PS=6.7e-06 NRD=0.085 NRS=0.085 $X=456600 $Y=160350 $D=41
M30 21 27 INN VDDA pmos4 L=3.5e-07 W=5e-06 AD=4.25e-12 AS=2.5e-12 PD=6.7e-06 PS=1e-06 NRD=0.085 NRS=0.085 $X=456600 $Y=161700 $D=41
M31 INP 27 20 VDDA pmos4 L=3.5e-07 W=5e-06 AD=2.5e-12 AS=4.25e-12 PD=1e-06 PS=6.7e-06 NRD=0.085 NRS=0.085 $X=456600 $Y=179075 $D=41
M32 20 27 INP VDDA pmos4 L=3.5e-07 W=5e-06 AD=4.25e-12 AS=2.5e-12 PD=6.7e-06 PS=1e-06 NRD=0.085 NRS=0.085 $X=456600 $Y=180425 $D=41
C33 22 VDDA $[cpolya] $A=875 $P=120 $X=16850 $Y=168650 $D=58
C34 GNDA BIAS $[cpolya] $A=1495.5 $P=159.7 $X=19525 $Y=94275 $D=58
C35 GNDA VDDA $[cpolya] $A=6400 $P=320 $X=59150 $Y=70600 $D=58
C36 GNDA VDDA $[cpolya] $A=600 $P=100 $X=170350 $Y=141600 $D=58
X37 VDDA 27 EN_CMFB pmos4_CDNS_7807366010349 $T=458575 140950 0 270 $X=457375 $Y=138350
X38 GNDA 27 EN_CMFB nmos4_CDNS_7807366010348 $T=458575 137125 0 270 $X=458325 $Y=135925
X39 14 BIAS BIAS GNDA nmos4_CDNS_7807366010386 $T=21475 75425 0 90 $X=12525 $Y=75025
X40 11 23 BIAS GNDA nmos4_CDNS_7807366010386 $T=30775 75425 0 90 $X=21825 $Y=75025
X43 GNDA 14 12 13 14 ICV_84 $T=39475 30100 0 90 $X=27525 $Y=29700
X44 GNDA 11 13 12 14 ICV_84 $T=39475 40800 0 90 $X=27525 $Y=40400
X45 GNDA 13 12 11 14 ICV_84 $T=90675 30100 0 90 $X=78725 $Y=29700
X46 GNDA 12 13 14 14 ICV_84 $T=90675 40800 0 90 $X=78725 $Y=40400
X74 VDDA 22 22 ICV_82 $T=76525 176550 0 90 $X=70625 $Y=175350
X75 VDDA 15 22 ICV_82 $T=76525 186350 0 90 $X=70625 $Y=185150
X76 VDDA 15 22 ICV_82 $T=87125 176550 0 90 $X=81225 $Y=175350
X77 VDDA 22 22 ICV_82 $T=87125 186350 0 90 $X=81225 $Y=185150
X82 22 23 23 VDDA pmos4_CDNS_7807366010373 $T=128250 176350 0 90 $X=122350 $Y=175150
X83 16 24 23 VDDA pmos4_CDNS_7807366010373 $T=133550 176350 0 90 $X=127650 $Y=175150
X84 15 10 23 VDDA pmos4_CDNS_7807366010373 $T=138850 176350 0 90 $X=132950 $Y=175150
X89 12 VDDA 13 INN INP GNDA ICV_81 $T=164175 175750 0 90 $X=161875 $Y=175350
X90 13 VDDA 12 INP INN GNDA ICV_81 $T=164175 188050 0 90 $X=161875 $Y=187650
X91 13 VDDA 12 INP INN GNDA ICV_81 $T=174775 175750 0 90 $X=172475 $Y=175350
X92 12 VDDA 13 INN INP GNDA ICV_81 $T=174775 188050 0 90 $X=172475 $Y=187650
X93 17 25 CM GNDA VDDA 18 CM 24 cmfb_opamp1_fc $T=159600 -12050 0 0 $X=164725 $Y=5998
X94 19 26 CMFB GNDA VDDA VREF_CM 18 10 cmfb_opamp1_fc $T=313550 -12050 0 0 $X=318675 $Y=5998
X95 18 13 rpolyhc_CDNS_7807366010384 $T=229125 146600 0 90 $X=208175 $Y=141250
X96 12 18 rpolyhc_CDNS_7807366010384 $T=252325 190750 1 270 $X=231375 $Y=141250
X99 20 CMFB GNDA rpolyhc_CDNS_7807366010393 $T=519650 188900 1 270 $X=469500 $Y=11300
X100 CMFB 21 GNDA rpolyhc_CDNS_7807366010393 $T=533550 17950 1 90 $X=527600 $Y=11300
.ENDS
***************************************
.SUBCKT V1000_20 VDD GND
** N=2 EP=2 IP=4 FDC=2
X0 VDD GND V500_20 $T=0 0 0 0 $X=-200 $Y=-50
X1 VDD GND V500_20 $T=500000 0 0 0 $X=499800 $Y=-50
.ENDS
***************************************
.SUBCKT V200_20 VDD GND
** N=3 EP=2 IP=0 FDC=1
C0 GND VDD $[cpolya] $A=3790.5 $P=419.9 $X=5575 $Y=3100 $D=58
.ENDS
***************************************
.SUBCKT pmos4_CDNS_7807366010364
** N=4 EP=0 IP=0 FDC=0
.ENDS
***************************************
.SUBCKT ICV_58
** N=6 EP=0 IP=8 FDC=0
.ENDS
***************************************
.SUBCKT ICV_59
** N=10 EP=0 IP=12 FDC=0
.ENDS
***************************************
.SUBCKT ICV_60 1
** N=13 EP=1 IP=34 FDC=2
M0 1 1 1 1 pmos4 L=1.5e-05 W=1e-05 AD=8.5e-12 AS=8.5e-12 PD=1.17e-05 PS=1.17e-05 NRD=0.0425 NRS=0.0425 $X=0 $Y=-206750 $D=42
M1 1 1 1 1 pmos4 L=1.5e-05 W=1e-05 AD=8.5e-12 AS=8.5e-12 PD=1.17e-05 PS=1.17e-05 NRD=0.0425 NRS=0.0425 $X=0 $Y=850 $D=42
.ENDS
***************************************
.SUBCKT ND_C_CDNS_78073660103274
** N=2 EP=0 IP=0 FDC=0
.ENDS
***************************************
.SUBCKT nmos4_CDNS_7807366010360 1 2 3 4
** N=4 EP=4 IP=0 FDC=2
M0 2 3 1 4 nmos4 L=2e-06 W=1e-05 AD=5e-12 AS=8.5e-12 PD=1e-06 PS=1.17e-05 NRD=0.0425 NRS=0.0425 $X=0 $Y=850 $D=37
M1 1 3 2 4 nmos4 L=2e-06 W=1e-05 AD=8.5e-12 AS=5e-12 PD=1.17e-05 PS=1e-06 NRD=0.0425 NRS=0.0425 $X=0 $Y=3850 $D=37
.ENDS
***************************************
.SUBCKT P2_C_CDNS_78073660103298
** N=2 EP=0 IP=0 FDC=0
.ENDS
***************************************
.SUBCKT PD_C_CDNS_78073660103278
** N=1 EP=0 IP=0 FDC=0
.ENDS
***************************************
.SUBCKT nmos4_CDNS_7807366010369 1 2 3
** N=3 EP=3 IP=0 FDC=1
M0 2 3 1 1 nmos4 L=2e-05 W=1.5e-05 AD=1.275e-11 AS=1.275e-11 PD=1.67e-05 PS=1.67e-05 NRD=0.0283333 NRS=0.0283333 $X=0 $Y=850 $D=37
.ENDS
***************************************
.SUBCKT P1_C_CDNS_78073660103271
** N=2 EP=0 IP=0 FDC=0
.ENDS
***************************************
.SUBCKT PD_C_CDNS_78073660103277
** N=1 EP=0 IP=0 FDC=0
.ENDS
***************************************
.SUBCKT nmos4_CDNS_7807366010370 1 2 3
** N=3 EP=3 IP=0 FDC=1
M0 2 3 1 1 nmos4 L=1.2e-05 W=1e-05 AD=8.5e-12 AS=8.5e-12 PD=1.17e-05 PS=1.17e-05 NRD=0.0425 NRS=0.0425 $X=0 $Y=850 $D=37
.ENDS
***************************************
.SUBCKT pmos4_CDNS_7807366010365 1 2
** N=2 EP=2 IP=0 FDC=10
M0 2 2 1 1 pmos4 L=3.5e-07 W=1e-05 AD=5e-12 AS=8.5e-12 PD=1e-06 PS=1.17e-05 NRD=0.0425 NRS=0.0425 $X=0 $Y=850 $D=41
M1 1 2 2 1 pmos4 L=3.5e-07 W=1e-05 AD=5e-12 AS=5e-12 PD=1e-06 PS=1e-06 NRD=0.0425 NRS=0.0425 $X=0 $Y=2200 $D=41
M2 2 2 1 1 pmos4 L=3.5e-07 W=1e-05 AD=5e-12 AS=5e-12 PD=1e-06 PS=1e-06 NRD=0.0425 NRS=0.0425 $X=0 $Y=3550 $D=41
M3 1 2 2 1 pmos4 L=3.5e-07 W=1e-05 AD=5e-12 AS=5e-12 PD=1e-06 PS=1e-06 NRD=0.0425 NRS=0.0425 $X=0 $Y=4900 $D=41
M4 2 2 1 1 pmos4 L=3.5e-07 W=1e-05 AD=5e-12 AS=5e-12 PD=1e-06 PS=1e-06 NRD=0.0425 NRS=0.0425 $X=0 $Y=6250 $D=41
M5 1 2 2 1 pmos4 L=3.5e-07 W=1e-05 AD=5e-12 AS=5e-12 PD=1e-06 PS=1e-06 NRD=0.0425 NRS=0.0425 $X=0 $Y=7600 $D=41
M6 2 2 1 1 pmos4 L=3.5e-07 W=1e-05 AD=5e-12 AS=5e-12 PD=1e-06 PS=1e-06 NRD=0.0425 NRS=0.0425 $X=0 $Y=8950 $D=41
M7 1 2 2 1 pmos4 L=3.5e-07 W=1e-05 AD=5e-12 AS=5e-12 PD=1e-06 PS=1e-06 NRD=0.0425 NRS=0.0425 $X=0 $Y=10300 $D=41
M8 2 2 1 1 pmos4 L=3.5e-07 W=1e-05 AD=5e-12 AS=5e-12 PD=1e-06 PS=1e-06 NRD=0.0425 NRS=0.0425 $X=0 $Y=11650 $D=41
M9 1 2 2 1 pmos4 L=3.5e-07 W=1e-05 AD=8.5e-12 AS=5e-12 PD=1.17e-05 PS=1e-06 NRD=0.0425 NRS=0.0425 $X=0 $Y=13000 $D=41
.ENDS
***************************************
.SUBCKT cpolyc_CDNS_7807366010368 2 3
** N=3 EP=2 IP=0 FDC=1
C0 2 3 $[cpolya] $A=1252.5 $P=143.5 $X=1800 $Y=1000 $D=58
.ENDS
***************************************
.SUBCKT rpolyhc_CDNS_7807366010363 1 2
** N=3 EP=2 IP=0 FDC=1
R0 1 2 L=0.00049995 W=8e-07 $[rpolyh] $X=-800 $Y=1550 $D=18
.ENDS
***************************************
.SUBCKT pmos4_CDNS_7807366010367 1 2 3 5
** N=5 EP=4 IP=0 FDC=2
M0 2 3 1 5 pmos4 L=3.5e-07 W=1e-05 AD=5e-12 AS=8.5e-12 PD=1e-06 PS=1.17e-05 NRD=0.0425 NRS=0.0425 $X=0 $Y=850 $D=41
M1 1 3 2 5 pmos4 L=3.5e-07 W=1e-05 AD=8.5e-12 AS=5e-12 PD=1.17e-05 PS=1e-06 NRD=0.0425 NRS=0.0425 $X=0 $Y=2200 $D=41
.ENDS
***************************************
.SUBCKT nmos4_CDNS_7807366010366 1 2 3 4
** N=4 EP=4 IP=0 FDC=1
M0 2 3 1 4 nmos4 L=3.5e-07 W=1e-05 AD=8.5e-12 AS=8.5e-12 PD=1.17e-05 PS=1.17e-05 NRD=0.0425 NRS=0.0425 $X=0 $Y=850 $D=37
.ENDS
***************************************
.SUBCKT mux21c_f A0 S C GNDA VDDA
** N=7 EP=5 IP=25 FDC=10
D0 GNDA VDDA p_nwd AREA=23.625 PJ=19.5 $X=2300 $Y=10500 $D=87
D1 GNDA VDDA p_nwd AREA=197.12 PJ=56.4 $X=7850 $Y=2100 $D=87
X2 VDDA 7 S pmos4_CDNS_7807366010349 $T=3525 13100 0 270 $X=2325 $Y=10500
X3 GNDA 7 S nmos4_CDNS_7807366010348 $T=3525 9125 0 270 $X=3275 $Y=7925
X4 A0 C S VDDA pmos4_CDNS_7807366010367 $T=13950 4800 0 90 $X=9350 $Y=3600
X5 A1 C 7 VDDA pmos4_CDNS_7807366010367 $T=17950 4800 0 90 $X=13350 $Y=3600
X6 C A1 S GNDA nmos4_CDNS_7807366010366 $T=23900 4800 0 90 $X=21600 $Y=4400
X7 C A0 7 GNDA nmos4_CDNS_7807366010366 $T=25000 4800 1 90 $X=24750 $Y=4400
.ENDS
***************************************
.SUBCKT cpolyc_CDNS_7807366010361 1 2
** N=2 EP=2 IP=0 FDC=1
C0 1 2 $[cpolya] $A=2097.5 $P=183.9 $X=1800 $Y=1000 $D=58
.ENDS
***************************************
.SUBCKT fecg_vga2_f_2 VOUT 2 3 VDDA BIAS GNDA CVGA S<0> S<1> S<2> VIN
** N=32 EP=11 IP=631 FDC=214
R0 13 19 L=0.00015005 W=2e-06 $[rpolyh] $X=357525 $Y=78550 $D=18
D1 GNDA VDDA p_nwd AREA=49208.1 PJ=902.6 $X=1450 $Y=12650 $D=87
D2 GNDA 2 p_nwd AREA=4905.73 PJ=289.9 $X=276300 $Y=140625 $D=87
D3 GNDA GNDA p_nwd AREA=844.025 PJ=116.7 $X=353225 $Y=73900 $D=87
D4 GNDA 3 p_nwd AREA=639.93 PJ=101.2 $X=357575 $Y=44750 $D=87
D5 GNDA GNDA p_nwd AREA=33433.7 PJ=736 $X=386425 $Y=32525 $D=87
M6 VOUT 13 GNDA GNDA nmos4 L=3.5e-07 W=2.5e-06 AD=1.25e-12 AS=2.125e-12 PD=1e-06 PS=4.2e-06 NRD=0.17 NRS=0.17 $X=363150 $Y=25175 $D=37
M7 GNDA 13 VOUT GNDA nmos4 L=3.5e-07 W=2.5e-06 AD=1.25e-12 AS=1.25e-12 PD=1e-06 PS=1e-06 NRD=0.17 NRS=0.17 $X=364500 $Y=25175 $D=37
M8 VOUT 13 GNDA GNDA nmos4 L=3.5e-07 W=2.5e-06 AD=1.25e-12 AS=1.25e-12 PD=1e-06 PS=1e-06 NRD=0.17 NRS=0.17 $X=365850 $Y=25175 $D=37
M9 GNDA 13 VOUT GNDA nmos4 L=3.5e-07 W=2.5e-06 AD=1.25e-12 AS=1.25e-12 PD=1e-06 PS=1e-06 NRD=0.17 NRS=0.17 $X=367200 $Y=25175 $D=37
M10 VOUT 13 GNDA GNDA nmos4 L=3.5e-07 W=2.5e-06 AD=1.25e-12 AS=1.25e-12 PD=1e-06 PS=1e-06 NRD=0.17 NRS=0.17 $X=368550 $Y=25175 $D=37
M11 GNDA 13 VOUT GNDA nmos4 L=3.5e-07 W=2.5e-06 AD=1.25e-12 AS=1.25e-12 PD=1e-06 PS=1e-06 NRD=0.17 NRS=0.17 $X=369900 $Y=25175 $D=37
M12 VOUT 13 GNDA GNDA nmos4 L=3.5e-07 W=2.5e-06 AD=1.25e-12 AS=1.25e-12 PD=1e-06 PS=1e-06 NRD=0.17 NRS=0.17 $X=371250 $Y=25175 $D=37
M13 GNDA 13 VOUT GNDA nmos4 L=3.5e-07 W=2.5e-06 AD=2.125e-12 AS=1.25e-12 PD=4.2e-06 PS=1e-06 NRD=0.17 NRS=0.17 $X=372600 $Y=25175 $D=37
M14 VDDA VDDA VDDA VDDA pmos4 L=1.5e-05 W=1e-05 AD=8.5e-12 AS=8.5e-12 PD=1.17e-05 PS=1.17e-05 NRD=0.0425 NRS=0.0425 $X=40950 $Y=18000 $D=42
M15 VDDA VDDA VDDA VDDA pmos4 L=1.5e-05 W=1e-05 AD=8.5e-12 AS=8.5e-12 PD=1.17e-05 PS=1.17e-05 NRD=0.0425 NRS=0.0425 $X=40950 $Y=39800 $D=42
M16 VDDA VDDA VDDA VDDA pmos4 L=1.5e-05 W=1e-05 AD=8.5e-12 AS=8.5e-12 PD=1.17e-05 PS=1.17e-05 NRD=0.0425 NRS=0.0425 $X=40950 $Y=148800 $D=42
M17 VDDA VDDA VDDA VDDA pmos4 L=1.5e-05 W=1e-05 AD=8.5e-12 AS=8.5e-12 PD=1.17e-05 PS=1.17e-05 NRD=0.0425 NRS=0.0425 $X=40950 $Y=170600 $D=42
M18 VDDA VDDA VDDA VDDA pmos4 L=1.5e-05 W=1e-05 AD=8.5e-12 AS=8.5e-12 PD=1.17e-05 PS=1.17e-05 NRD=0.0425 NRS=0.0425 $X=58250 $Y=18000 $D=42
M19 VDDA VDDA VDDA VDDA pmos4 L=1.5e-05 W=1e-05 AD=8.5e-12 AS=8.5e-12 PD=1.17e-05 PS=1.17e-05 NRD=0.0425 NRS=0.0425 $X=58250 $Y=170600 $D=42
M20 VDDA VDDA VDDA VDDA pmos4 L=1.5e-05 W=1e-05 AD=8.5e-12 AS=8.5e-12 PD=1.17e-05 PS=1.17e-05 NRD=0.0425 NRS=0.0425 $X=75550 $Y=18000 $D=42
M21 VDDA VDDA VDDA VDDA pmos4 L=1.5e-05 W=1e-05 AD=8.5e-12 AS=8.5e-12 PD=1.17e-05 PS=1.17e-05 NRD=0.0425 NRS=0.0425 $X=75550 $Y=170600 $D=42
M22 VDDA VDDA VDDA VDDA pmos4 L=1.5e-05 W=1e-05 AD=8.5e-12 AS=8.5e-12 PD=1.17e-05 PS=1.17e-05 NRD=0.0425 NRS=0.0425 $X=92850 $Y=18000 $D=42
M23 VDDA VDDA VDDA VDDA pmos4 L=1.5e-05 W=1e-05 AD=8.5e-12 AS=8.5e-12 PD=1.17e-05 PS=1.17e-05 NRD=0.0425 NRS=0.0425 $X=92850 $Y=170600 $D=42
M24 VDDA VDDA VDDA VDDA pmos4 L=1.5e-05 W=1e-05 AD=8.5e-12 AS=8.5e-12 PD=1.17e-05 PS=1.17e-05 NRD=0.0425 NRS=0.0425 $X=110150 $Y=18000 $D=42
M25 VDDA VDDA VDDA VDDA pmos4 L=1.5e-05 W=1e-05 AD=8.5e-12 AS=8.5e-12 PD=1.17e-05 PS=1.17e-05 NRD=0.0425 NRS=0.0425 $X=110150 $Y=170600 $D=42
M26 VDDA VDDA VDDA VDDA pmos4 L=1.5e-05 W=1e-05 AD=8.5e-12 AS=8.5e-12 PD=1.17e-05 PS=1.17e-05 NRD=0.0425 NRS=0.0425 $X=127450 $Y=18000 $D=42
M27 VDDA VDDA VDDA VDDA pmos4 L=1.5e-05 W=1e-05 AD=8.5e-12 AS=8.5e-12 PD=1.17e-05 PS=1.17e-05 NRD=0.0425 NRS=0.0425 $X=127450 $Y=170600 $D=42
M28 VDDA VDDA VDDA VDDA pmos4 L=1.5e-05 W=1e-05 AD=8.5e-12 AS=8.5e-12 PD=1.17e-05 PS=1.17e-05 NRD=0.0425 NRS=0.0425 $X=144750 $Y=18000 $D=42
M29 VDDA VDDA VDDA VDDA pmos4 L=1.5e-05 W=1e-05 AD=8.5e-12 AS=8.5e-12 PD=1.17e-05 PS=1.17e-05 NRD=0.0425 NRS=0.0425 $X=144750 $Y=170600 $D=42
M30 VDDA VDDA VDDA VDDA pmos4 L=1.5e-05 W=1e-05 AD=8.5e-12 AS=8.5e-12 PD=1.17e-05 PS=1.17e-05 NRD=0.0425 NRS=0.0425 $X=162050 $Y=18000 $D=42
M31 VDDA VDDA VDDA VDDA pmos4 L=1.5e-05 W=1e-05 AD=8.5e-12 AS=8.5e-12 PD=1.17e-05 PS=1.17e-05 NRD=0.0425 NRS=0.0425 $X=162050 $Y=170600 $D=42
M32 VDDA VDDA VDDA VDDA pmos4 L=1.5e-05 W=1e-05 AD=8.5e-12 AS=8.5e-12 PD=1.17e-05 PS=1.17e-05 NRD=0.0425 NRS=0.0425 $X=179350 $Y=18000 $D=42
M33 VDDA VDDA VDDA VDDA pmos4 L=1.5e-05 W=1e-05 AD=8.5e-12 AS=8.5e-12 PD=1.17e-05 PS=1.17e-05 NRD=0.0425 NRS=0.0425 $X=179350 $Y=170600 $D=42
M34 VDDA VDDA VDDA VDDA pmos4 L=1.5e-05 W=1e-05 AD=8.5e-12 AS=8.5e-12 PD=1.17e-05 PS=1.17e-05 NRD=0.0425 NRS=0.0425 $X=196650 $Y=18000 $D=42
M35 VDDA VDDA VDDA VDDA pmos4 L=1.5e-05 W=1e-05 AD=8.5e-12 AS=8.5e-12 PD=1.17e-05 PS=1.17e-05 NRD=0.0425 NRS=0.0425 $X=196650 $Y=170600 $D=42
M36 VDDA VDDA VDDA VDDA pmos4 L=1.5e-05 W=1e-05 AD=8.5e-12 AS=8.5e-12 PD=1.17e-05 PS=1.17e-05 NRD=0.0425 NRS=0.0425 $X=213950 $Y=18000 $D=42
M37 VDDA VDDA VDDA VDDA pmos4 L=1.5e-05 W=1e-05 AD=8.5e-12 AS=8.5e-12 PD=1.17e-05 PS=1.17e-05 NRD=0.0425 NRS=0.0425 $X=213950 $Y=148800 $D=42
M38 VDDA VDDA VDDA VDDA pmos4 L=1.5e-05 W=1e-05 AD=8.5e-12 AS=8.5e-12 PD=1.17e-05 PS=1.17e-05 NRD=0.0425 NRS=0.0425 $X=213950 $Y=170600 $D=42
M39 2 2 2 2 pmos4 L=4e-06 W=1.25e-05 AD=1.0625e-11 AS=1.0625e-11 PD=1.42e-05 PS=1.42e-05 NRD=0.034 NRS=0.034 $X=291500 $Y=151975 $D=42
M40 2 2 2 2 pmos4 L=4e-06 W=1.25e-05 AD=1.0625e-11 AS=1.0625e-11 PD=1.42e-05 PS=1.42e-05 NRD=0.034 NRS=0.034 $X=291500 $Y=170625 $D=42
M41 2 2 2 2 pmos4 L=4e-06 W=1.25e-05 AD=1.0625e-11 AS=1.0625e-11 PD=1.42e-05 PS=1.42e-05 NRD=0.034 NRS=0.034 $X=348200 $Y=151975 $D=42
M42 2 2 2 2 pmos4 L=4e-06 W=1.25e-05 AD=1.0625e-11 AS=1.0625e-11 PD=1.42e-05 PS=1.42e-05 NRD=0.034 NRS=0.034 $X=348200 $Y=170625 $D=42
M43 VDDA 12 VOUT VDDA pmos4 L=1.5e-05 W=1e-05 AD=8.5e-12 AS=8.5e-12 PD=1.17e-05 PS=1.17e-05 NRD=0.0425 NRS=0.0425 $X=40950 $Y=61600 $D=41
M44 VDDA 12 VOUT VDDA pmos4 L=1.5e-05 W=1e-05 AD=8.5e-12 AS=8.5e-12 PD=1.17e-05 PS=1.17e-05 NRD=0.0425 NRS=0.0425 $X=40950 $Y=83400 $D=41
M45 VDDA 12 VOUT VDDA pmos4 L=1.5e-05 W=1e-05 AD=8.5e-12 AS=8.5e-12 PD=1.17e-05 PS=1.17e-05 NRD=0.0425 NRS=0.0425 $X=40950 $Y=105200 $D=41
M46 VDDA 12 VOUT VDDA pmos4 L=1.5e-05 W=1e-05 AD=8.5e-12 AS=8.5e-12 PD=1.17e-05 PS=1.17e-05 NRD=0.0425 NRS=0.0425 $X=40950 $Y=127000 $D=41
M47 VDDA 12 VOUT VDDA pmos4 L=1.5e-05 W=1e-05 AD=8.5e-12 AS=8.5e-12 PD=1.17e-05 PS=1.17e-05 NRD=0.0425 NRS=0.0425 $X=58250 $Y=39800 $D=41
M48 VDDA 12 VOUT VDDA pmos4 L=1.5e-05 W=1e-05 AD=8.5e-12 AS=8.5e-12 PD=1.17e-05 PS=1.17e-05 NRD=0.0425 NRS=0.0425 $X=58250 $Y=61600 $D=41
M49 VDDA 12 2 VDDA pmos4 L=1.5e-05 W=1e-05 AD=8.5e-12 AS=8.5e-12 PD=1.17e-05 PS=1.17e-05 NRD=0.0425 NRS=0.0425 $X=58250 $Y=83400 $D=41
M50 VDDA 12 VOUT VDDA pmos4 L=1.5e-05 W=1e-05 AD=8.5e-12 AS=8.5e-12 PD=1.17e-05 PS=1.17e-05 NRD=0.0425 NRS=0.0425 $X=58250 $Y=105200 $D=41
M51 VDDA 12 2 VDDA pmos4 L=1.5e-05 W=1e-05 AD=8.5e-12 AS=8.5e-12 PD=1.17e-05 PS=1.17e-05 NRD=0.0425 NRS=0.0425 $X=58250 $Y=127000 $D=41
M52 VDDA 12 VOUT VDDA pmos4 L=1.5e-05 W=1e-05 AD=8.5e-12 AS=8.5e-12 PD=1.17e-05 PS=1.17e-05 NRD=0.0425 NRS=0.0425 $X=58250 $Y=148800 $D=41
M53 VDDA 12 VOUT VDDA pmos4 L=1.5e-05 W=1e-05 AD=8.5e-12 AS=8.5e-12 PD=1.17e-05 PS=1.17e-05 NRD=0.0425 NRS=0.0425 $X=75550 $Y=39800 $D=41
M54 VDDA 12 2 VDDA pmos4 L=1.5e-05 W=1e-05 AD=8.5e-12 AS=8.5e-12 PD=1.17e-05 PS=1.17e-05 NRD=0.0425 NRS=0.0425 $X=75550 $Y=61600 $D=41
M55 VDDA 12 VOUT VDDA pmos4 L=1.5e-05 W=1e-05 AD=8.5e-12 AS=8.5e-12 PD=1.17e-05 PS=1.17e-05 NRD=0.0425 NRS=0.0425 $X=75550 $Y=83400 $D=41
M56 VDDA 12 12 VDDA pmos4 L=1.5e-05 W=1e-05 AD=8.5e-12 AS=8.5e-12 PD=1.17e-05 PS=1.17e-05 NRD=0.0425 NRS=0.0425 $X=75550 $Y=105200 $D=41
M57 VDDA 12 VOUT VDDA pmos4 L=1.5e-05 W=1e-05 AD=8.5e-12 AS=8.5e-12 PD=1.17e-05 PS=1.17e-05 NRD=0.0425 NRS=0.0425 $X=75550 $Y=127000 $D=41
M58 VDDA 12 VOUT VDDA pmos4 L=1.5e-05 W=1e-05 AD=8.5e-12 AS=8.5e-12 PD=1.17e-05 PS=1.17e-05 NRD=0.0425 NRS=0.0425 $X=75550 $Y=148800 $D=41
M59 VDDA 12 VOUT VDDA pmos4 L=1.5e-05 W=1e-05 AD=8.5e-12 AS=8.5e-12 PD=1.17e-05 PS=1.17e-05 NRD=0.0425 NRS=0.0425 $X=92850 $Y=39800 $D=41
M60 VDDA 12 VOUT VDDA pmos4 L=1.5e-05 W=1e-05 AD=8.5e-12 AS=8.5e-12 PD=1.17e-05 PS=1.17e-05 NRD=0.0425 NRS=0.0425 $X=92850 $Y=61600 $D=41
M61 VDDA 12 2 VDDA pmos4 L=1.5e-05 W=1e-05 AD=8.5e-12 AS=8.5e-12 PD=1.17e-05 PS=1.17e-05 NRD=0.0425 NRS=0.0425 $X=92850 $Y=83400 $D=41
M62 VDDA 12 VOUT VDDA pmos4 L=1.5e-05 W=1e-05 AD=8.5e-12 AS=8.5e-12 PD=1.17e-05 PS=1.17e-05 NRD=0.0425 NRS=0.0425 $X=92850 $Y=105200 $D=41
M63 VDDA 12 2 VDDA pmos4 L=1.5e-05 W=1e-05 AD=8.5e-12 AS=8.5e-12 PD=1.17e-05 PS=1.17e-05 NRD=0.0425 NRS=0.0425 $X=92850 $Y=127000 $D=41
M64 VDDA 12 VOUT VDDA pmos4 L=1.5e-05 W=1e-05 AD=8.5e-12 AS=8.5e-12 PD=1.17e-05 PS=1.17e-05 NRD=0.0425 NRS=0.0425 $X=92850 $Y=148800 $D=41
M65 VDDA 12 VOUT VDDA pmos4 L=1.5e-05 W=1e-05 AD=8.5e-12 AS=8.5e-12 PD=1.17e-05 PS=1.17e-05 NRD=0.0425 NRS=0.0425 $X=110150 $Y=39800 $D=41
M66 VDDA 12 VOUT VDDA pmos4 L=1.5e-05 W=1e-05 AD=8.5e-12 AS=8.5e-12 PD=1.17e-05 PS=1.17e-05 NRD=0.0425 NRS=0.0425 $X=110150 $Y=61600 $D=41
M67 VDDA 12 VOUT VDDA pmos4 L=1.5e-05 W=1e-05 AD=8.5e-12 AS=8.5e-12 PD=1.17e-05 PS=1.17e-05 NRD=0.0425 NRS=0.0425 $X=110150 $Y=83400 $D=41
M68 VDDA 12 VOUT VDDA pmos4 L=1.5e-05 W=1e-05 AD=8.5e-12 AS=8.5e-12 PD=1.17e-05 PS=1.17e-05 NRD=0.0425 NRS=0.0425 $X=110150 $Y=105200 $D=41
M69 VDDA 12 VOUT VDDA pmos4 L=1.5e-05 W=1e-05 AD=8.5e-12 AS=8.5e-12 PD=1.17e-05 PS=1.17e-05 NRD=0.0425 NRS=0.0425 $X=110150 $Y=127000 $D=41
M70 VDDA 12 VOUT VDDA pmos4 L=1.5e-05 W=1e-05 AD=8.5e-12 AS=8.5e-12 PD=1.17e-05 PS=1.17e-05 NRD=0.0425 NRS=0.0425 $X=110150 $Y=148800 $D=41
M71 VDDA 12 VOUT VDDA pmos4 L=1.5e-05 W=1e-05 AD=8.5e-12 AS=8.5e-12 PD=1.17e-05 PS=1.17e-05 NRD=0.0425 NRS=0.0425 $X=127450 $Y=39800 $D=41
M72 VDDA 12 VOUT VDDA pmos4 L=1.5e-05 W=1e-05 AD=8.5e-12 AS=8.5e-12 PD=1.17e-05 PS=1.17e-05 NRD=0.0425 NRS=0.0425 $X=127450 $Y=61600 $D=41
M73 VDDA 12 VOUT VDDA pmos4 L=1.5e-05 W=1e-05 AD=8.5e-12 AS=8.5e-12 PD=1.17e-05 PS=1.17e-05 NRD=0.0425 NRS=0.0425 $X=127450 $Y=83400 $D=41
M74 VDDA 12 3 VDDA pmos4 L=1.5e-05 W=1e-05 AD=8.5e-12 AS=8.5e-12 PD=1.17e-05 PS=1.17e-05 NRD=0.0425 NRS=0.0425 $X=127450 $Y=105200 $D=41
M75 VDDA 12 VOUT VDDA pmos4 L=1.5e-05 W=1e-05 AD=8.5e-12 AS=8.5e-12 PD=1.17e-05 PS=1.17e-05 NRD=0.0425 NRS=0.0425 $X=127450 $Y=127000 $D=41
M76 VDDA 12 VOUT VDDA pmos4 L=1.5e-05 W=1e-05 AD=8.5e-12 AS=8.5e-12 PD=1.17e-05 PS=1.17e-05 NRD=0.0425 NRS=0.0425 $X=127450 $Y=148800 $D=41
M77 VDDA 12 VOUT VDDA pmos4 L=1.5e-05 W=1e-05 AD=8.5e-12 AS=8.5e-12 PD=1.17e-05 PS=1.17e-05 NRD=0.0425 NRS=0.0425 $X=144750 $Y=39800 $D=41
M78 VDDA 12 VOUT VDDA pmos4 L=1.5e-05 W=1e-05 AD=8.5e-12 AS=8.5e-12 PD=1.17e-05 PS=1.17e-05 NRD=0.0425 NRS=0.0425 $X=144750 $Y=61600 $D=41
M79 VDDA 12 VOUT VDDA pmos4 L=1.5e-05 W=1e-05 AD=8.5e-12 AS=8.5e-12 PD=1.17e-05 PS=1.17e-05 NRD=0.0425 NRS=0.0425 $X=144750 $Y=83400 $D=41
M80 VDDA 12 VOUT VDDA pmos4 L=1.5e-05 W=1e-05 AD=8.5e-12 AS=8.5e-12 PD=1.17e-05 PS=1.17e-05 NRD=0.0425 NRS=0.0425 $X=144750 $Y=105200 $D=41
M81 VDDA 12 VOUT VDDA pmos4 L=1.5e-05 W=1e-05 AD=8.5e-12 AS=8.5e-12 PD=1.17e-05 PS=1.17e-05 NRD=0.0425 NRS=0.0425 $X=144750 $Y=127000 $D=41
M82 VDDA 12 VOUT VDDA pmos4 L=1.5e-05 W=1e-05 AD=8.5e-12 AS=8.5e-12 PD=1.17e-05 PS=1.17e-05 NRD=0.0425 NRS=0.0425 $X=144750 $Y=148800 $D=41
M83 VDDA 12 VOUT VDDA pmos4 L=1.5e-05 W=1e-05 AD=8.5e-12 AS=8.5e-12 PD=1.17e-05 PS=1.17e-05 NRD=0.0425 NRS=0.0425 $X=162050 $Y=39800 $D=41
M84 VDDA 12 2 VDDA pmos4 L=1.5e-05 W=1e-05 AD=8.5e-12 AS=8.5e-12 PD=1.17e-05 PS=1.17e-05 NRD=0.0425 NRS=0.0425 $X=162050 $Y=61600 $D=41
M85 VDDA 12 VOUT VDDA pmos4 L=1.5e-05 W=1e-05 AD=8.5e-12 AS=8.5e-12 PD=1.17e-05 PS=1.17e-05 NRD=0.0425 NRS=0.0425 $X=162050 $Y=83400 $D=41
M86 VDDA 12 2 VDDA pmos4 L=1.5e-05 W=1e-05 AD=8.5e-12 AS=8.5e-12 PD=1.17e-05 PS=1.17e-05 NRD=0.0425 NRS=0.0425 $X=162050 $Y=105200 $D=41
M87 VDDA 12 VOUT VDDA pmos4 L=1.5e-05 W=1e-05 AD=8.5e-12 AS=8.5e-12 PD=1.17e-05 PS=1.17e-05 NRD=0.0425 NRS=0.0425 $X=162050 $Y=127000 $D=41
M88 VDDA 12 VOUT VDDA pmos4 L=1.5e-05 W=1e-05 AD=8.5e-12 AS=8.5e-12 PD=1.17e-05 PS=1.17e-05 NRD=0.0425 NRS=0.0425 $X=162050 $Y=148800 $D=41
M89 VDDA 12 VOUT VDDA pmos4 L=1.5e-05 W=1e-05 AD=8.5e-12 AS=8.5e-12 PD=1.17e-05 PS=1.17e-05 NRD=0.0425 NRS=0.0425 $X=179350 $Y=39800 $D=41
M90 VDDA 12 VOUT VDDA pmos4 L=1.5e-05 W=1e-05 AD=8.5e-12 AS=8.5e-12 PD=1.17e-05 PS=1.17e-05 NRD=0.0425 NRS=0.0425 $X=179350 $Y=61600 $D=41
M91 VDDA 12 12 VDDA pmos4 L=1.5e-05 W=1e-05 AD=8.5e-12 AS=8.5e-12 PD=1.17e-05 PS=1.17e-05 NRD=0.0425 NRS=0.0425 $X=179350 $Y=83400 $D=41
M92 VDDA 12 VOUT VDDA pmos4 L=1.5e-05 W=1e-05 AD=8.5e-12 AS=8.5e-12 PD=1.17e-05 PS=1.17e-05 NRD=0.0425 NRS=0.0425 $X=179350 $Y=105200 $D=41
M93 VDDA 12 2 VDDA pmos4 L=1.5e-05 W=1e-05 AD=8.5e-12 AS=8.5e-12 PD=1.17e-05 PS=1.17e-05 NRD=0.0425 NRS=0.0425 $X=179350 $Y=127000 $D=41
M94 VDDA 12 VOUT VDDA pmos4 L=1.5e-05 W=1e-05 AD=8.5e-12 AS=8.5e-12 PD=1.17e-05 PS=1.17e-05 NRD=0.0425 NRS=0.0425 $X=179350 $Y=148800 $D=41
M95 VDDA 12 VOUT VDDA pmos4 L=1.5e-05 W=1e-05 AD=8.5e-12 AS=8.5e-12 PD=1.17e-05 PS=1.17e-05 NRD=0.0425 NRS=0.0425 $X=196650 $Y=39800 $D=41
M96 VDDA 12 2 VDDA pmos4 L=1.5e-05 W=1e-05 AD=8.5e-12 AS=8.5e-12 PD=1.17e-05 PS=1.17e-05 NRD=0.0425 NRS=0.0425 $X=196650 $Y=61600 $D=41
M97 VDDA 12 VOUT VDDA pmos4 L=1.5e-05 W=1e-05 AD=8.5e-12 AS=8.5e-12 PD=1.17e-05 PS=1.17e-05 NRD=0.0425 NRS=0.0425 $X=196650 $Y=83400 $D=41
M98 VDDA 12 2 VDDA pmos4 L=1.5e-05 W=1e-05 AD=8.5e-12 AS=8.5e-12 PD=1.17e-05 PS=1.17e-05 NRD=0.0425 NRS=0.0425 $X=196650 $Y=105200 $D=41
M99 VDDA 12 VOUT VDDA pmos4 L=1.5e-05 W=1e-05 AD=8.5e-12 AS=8.5e-12 PD=1.17e-05 PS=1.17e-05 NRD=0.0425 NRS=0.0425 $X=196650 $Y=127000 $D=41
M100 VDDA 12 VOUT VDDA pmos4 L=1.5e-05 W=1e-05 AD=8.5e-12 AS=8.5e-12 PD=1.17e-05 PS=1.17e-05 NRD=0.0425 NRS=0.0425 $X=196650 $Y=148800 $D=41
M101 VDDA 12 VOUT VDDA pmos4 L=1.5e-05 W=1e-05 AD=8.5e-12 AS=8.5e-12 PD=1.17e-05 PS=1.17e-05 NRD=0.0425 NRS=0.0425 $X=213950 $Y=39800 $D=41
M102 VDDA 12 VOUT VDDA pmos4 L=1.5e-05 W=1e-05 AD=8.5e-12 AS=8.5e-12 PD=1.17e-05 PS=1.17e-05 NRD=0.0425 NRS=0.0425 $X=213950 $Y=61600 $D=41
M103 VDDA 12 VOUT VDDA pmos4 L=1.5e-05 W=1e-05 AD=8.5e-12 AS=8.5e-12 PD=1.17e-05 PS=1.17e-05 NRD=0.0425 NRS=0.0425 $X=213950 $Y=83400 $D=41
M104 VDDA 12 VOUT VDDA pmos4 L=1.5e-05 W=1e-05 AD=8.5e-12 AS=8.5e-12 PD=1.17e-05 PS=1.17e-05 NRD=0.0425 NRS=0.0425 $X=213950 $Y=105200 $D=41
M105 VDDA 12 VOUT VDDA pmos4 L=1.5e-05 W=1e-05 AD=8.5e-12 AS=8.5e-12 PD=1.17e-05 PS=1.17e-05 NRD=0.0425 NRS=0.0425 $X=213950 $Y=127000 $D=41
M106 14 21 2 2 pmos4 L=4e-06 W=1.25e-05 AD=1.0625e-11 AS=1.0625e-11 PD=1.42e-05 PS=1.42e-05 NRD=0.034 NRS=0.034 $X=316700 $Y=151975 $D=41
M107 13 VIN 2 2 pmos4 L=4e-06 W=1.25e-05 AD=1.0625e-11 AS=1.0625e-11 PD=1.42e-05 PS=1.42e-05 NRD=0.034 NRS=0.034 $X=316700 $Y=170625 $D=41
M108 13 VIN 2 2 pmos4 L=4e-06 W=1.25e-05 AD=1.0625e-11 AS=1.0625e-11 PD=1.42e-05 PS=1.42e-05 NRD=0.034 NRS=0.034 $X=341900 $Y=151975 $D=41
M109 14 21 2 2 pmos4 L=4e-06 W=1.25e-05 AD=1.0625e-11 AS=1.0625e-11 PD=1.42e-05 PS=1.42e-05 NRD=0.034 NRS=0.034 $X=341900 $Y=170625 $D=41
C110 GNDA BIAS $[cpolya] $A=341.145 $P=73.9 $X=274550 $Y=50950 $D=58
X217 2 13 14 VIN 21 ICV_110 $T=290650 164475 0 270 $X=289450 $Y=150775
X218 2 14 13 21 VIN ICV_110 $T=290650 183125 0 270 $X=289450 $Y=169425
X219 2 14 13 21 VIN ICV_110 $T=315850 164475 0 270 $X=314650 $Y=150775
X220 2 13 14 VIN 21 ICV_110 $T=315850 183125 0 270 $X=314650 $Y=169425
X225 VDDA ICV_60 $T=39500 18000 0 90 $X=21600 $Y=16800
X226 VDDA ICV_60 $T=39500 39800 0 90 $X=21600 $Y=38600
X227 VDDA ICV_60 $T=39500 61600 0 90 $X=21600 $Y=60400
X228 VDDA ICV_60 $T=39500 83400 0 90 $X=21600 $Y=82200
X229 VDDA ICV_60 $T=39500 105200 0 90 $X=21600 $Y=104000
X230 VDDA ICV_60 $T=39500 127000 0 90 $X=21600 $Y=125800
X231 VDDA ICV_60 $T=39500 148800 0 90 $X=21600 $Y=147600
X232 VDDA ICV_60 $T=39500 170600 0 90 $X=21600 $Y=169400
X298 16 BIAS BIAS GNDA nmos4_CDNS_7807366010360 $T=274250 37000 0 270 $X=274000 $Y=26600
X299 15 12 BIAS GNDA nmos4_CDNS_7807366010360 $T=281550 37000 0 270 $X=281300 $Y=26600
X306 GNDA 14 14 nmos4_CDNS_7807366010369 $T=311550 87650 0 90 $X=289600 $Y=87250
X307 GNDA 13 14 nmos4_CDNS_7807366010369 $T=311550 106050 0 90 $X=289600 $Y=105650
X308 GNDA 13 14 nmos4_CDNS_7807366010369 $T=334350 87650 0 90 $X=312400 $Y=87250
X309 GNDA 14 14 nmos4_CDNS_7807366010369 $T=334350 106050 0 90 $X=312400 $Y=105650
X318 GNDA 15 16 nmos4_CDNS_7807366010370 $T=312425 37375 0 270 $X=312175 $Y=26975
X319 GNDA 16 16 nmos4_CDNS_7807366010370 $T=312425 50775 0 270 $X=312175 $Y=40375
X320 GNDA 16 16 nmos4_CDNS_7807366010370 $T=326725 37375 0 270 $X=326475 $Y=26975
X321 GNDA 15 16 nmos4_CDNS_7807366010370 $T=326725 50775 0 270 $X=326475 $Y=40375
X322 3 GNDA pmos4_CDNS_7807366010365 $T=377125 55100 0 90 $X=361725 $Y=53900
X323 VOUT 19 cpolyc_CDNS_7807366010368 $T=432325 156275 0 180 $X=386425 $Y=122925
X324 VOUT 19 cpolyc_CDNS_7807366010368 $T=432325 193225 0 180 $X=386425 $Y=159875
X325 VOUT 19 cpolyc_CDNS_7807366010368 $T=481575 156275 0 180 $X=435675 $Y=122925
X326 VOUT 19 cpolyc_CDNS_7807366010368 $T=481575 193225 0 180 $X=435675 $Y=159875
X327 VOUT 19 cpolyc_CDNS_7807366010368 $T=531025 156275 0 180 $X=485125 $Y=122925
X328 VOUT 19 cpolyc_CDNS_7807366010368 $T=531025 193225 0 180 $X=485125 $Y=159875
X329 21 CVGA rpolyhc_CDNS_7807366010363 $T=437475 55175 0 180 $X=387975 $Y=34225
X330 17 21 rpolyhc_CDNS_7807366010363 $T=393325 74775 1 0 $X=387975 $Y=53825
X331 22 17 rpolyhc_CDNS_7807366010363 $T=437475 94375 0 180 $X=387975 $Y=73425
X332 18 22 rpolyhc_CDNS_7807366010363 $T=393325 113975 1 0 $X=387975 $Y=93025
X333 20 24 rpolyhc_CDNS_7807366010363 $T=442175 38875 0 0 $X=436825 $Y=34225
X334 24 23 rpolyhc_CDNS_7807366010363 $T=486325 58475 1 180 $X=436825 $Y=53825
X335 23 25 rpolyhc_CDNS_7807366010363 $T=442175 78075 0 0 $X=436825 $Y=73425
X336 25 18 rpolyhc_CDNS_7807366010363 $T=486325 97675 1 180 $X=436825 $Y=93025
X337 27 20 rpolyhc_CDNS_7807366010363 $T=535175 55175 0 180 $X=485675 $Y=34225
X338 26 27 rpolyhc_CDNS_7807366010363 $T=491025 74775 1 0 $X=485675 $Y=53825
X339 28 26 rpolyhc_CDNS_7807366010363 $T=535175 94375 0 180 $X=485675 $Y=73425
X340 30 28 rpolyhc_CDNS_7807366010363 $T=491025 113975 1 0 $X=485675 $Y=93025
X341 VOUT 31 rpolyhc_CDNS_7807366010363 $T=539875 38875 0 0 $X=534525 $Y=34225
X342 31 29 rpolyhc_CDNS_7807366010363 $T=584025 58475 1 180 $X=534525 $Y=53825
X343 29 32 rpolyhc_CDNS_7807366010363 $T=539875 78075 0 0 $X=534525 $Y=73425
X344 32 30 rpolyhc_CDNS_7807366010363 $T=584025 97675 1 180 $X=534525 $Y=93025
X345 17 S<0> 18 GNDA VDDA mux21c_f $T=409500 11925 0 0 $X=409850 $Y=12275
X346 18 S<1> 20 GNDA VDDA mux21c_f $T=472300 11925 0 0 $X=472650 $Y=12275
X347 20 S<2> VOUT GNDA VDDA mux21c_f $T=538600 11925 0 0 $X=538950 $Y=12275
X348 GNDA VDDA cpolyc_CDNS_7807366010361 $T=588250 149275 1 180 $X=534100 $Y=147925
.ENDS
***************************************
.SUBCKT cpolyc_CDNS_78073660103112 1 2
** N=2 EP=2 IP=0 FDC=1
C0 1 2 $[cpolya] $A=1000 $P=130 $X=1800 $Y=1000 $D=58
.ENDS
***************************************
.SUBCKT nmos4_CDNS_780736601036
** N=4 EP=0 IP=0 FDC=0
.ENDS
***************************************
.SUBCKT pmos4_CDNS_78073660103111
** N=4 EP=0 IP=0 FDC=0
.ENDS
***************************************
.SUBCKT ICV_106
** N=6 EP=0 IP=8 FDC=0
.ENDS
***************************************
.SUBCKT ICV_107 1 3 4 6 7
** N=8 EP=5 IP=12 FDC=3
M0 3 6 1 1 pmos4 L=5e-07 W=1.25e-05 AD=1.0625e-11 AS=1.0625e-11 PD=1.42e-05 PS=1.42e-05 NRD=0.034 NRS=0.034 $X=0 $Y=3650 $D=41
M1 4 7 1 1 pmos4 L=5e-07 W=1.25e-05 AD=1.0625e-11 AS=1.0625e-11 PD=1.42e-05 PS=1.42e-05 NRD=0.034 NRS=0.034 $X=0 $Y=6450 $D=41
M2 3 6 1 1 pmos4 L=5e-07 W=1.25e-05 AD=1.0625e-11 AS=1.0625e-11 PD=1.42e-05 PS=1.42e-05 NRD=0.034 NRS=0.034 $X=0 $Y=9250 $D=41
.ENDS
***************************************
.SUBCKT ICV_108 1 3 4 6 7
** N=8 EP=5 IP=16 FDC=7
M0 4 7 1 1 pmos4 L=5e-07 W=1.25e-05 AD=1.0625e-11 AS=1.0625e-11 PD=1.42e-05 PS=1.42e-05 NRD=0.034 NRS=0.034 $X=0 $Y=12050 $D=41
X1 1 3 4 6 7 ICV_107 $T=0 0 0 0 $X=-1200 $Y=-1200
X2 1 3 4 6 7 ICV_107 $T=0 11200 0 0 $X=-1200 $Y=10000
.ENDS
***************************************
.SUBCKT rpolyhc_CDNS_78073660103114 2 3
** N=3 EP=2 IP=0 FDC=1
R0 2 3 L=0.0010002 W=8e-07 $[rpolyh] $X=-800 $Y=1550 $D=18
.ENDS
***************************************
.SUBCKT cpolyc_CDNS_78073660103110 2 3
** N=3 EP=2 IP=0 FDC=1
C0 2 3 $[cpolya] $A=1600 $P=164 $X=1800 $Y=1000 $D=58
.ENDS
***************************************
.SUBCKT buffer2_f_3c BIAS GNDA OUT INP VDDA CBUF
** N=14 EP=6 IP=224 FDC=144
R0 9 12 L=7.50901e-05 W=2e-06 $[rpolyh] $X=187775 $Y=114900 $D=17
D1 GNDA 10 p_nwd AREA=6843.15 PJ=357.6 $X=43125 $Y=62125 $D=87
D2 GNDA VDDA p_nwd AREA=5496.3 PJ=329.4 $X=43950 $Y=125575 $D=87
D3 GNDA GNDA p_nwd AREA=605.64 PJ=105.7 $X=183475 $Y=106150 $D=87
D4 GNDA GNDA p_nwd AREA=4942.84 PJ=289 $X=171550 $Y=13500 $D=87
M5 7 8 GNDA GNDA nmos4 L=1e-05 W=1e-05 AD=8.5e-12 AS=8.5e-12 PD=1.17e-05 PS=1.17e-05 NRD=0.0425 NRS=0.0425 $X=18150 $Y=22825 $D=37
M6 8 8 GNDA GNDA nmos4 L=1e-05 W=1e-05 AD=8.5e-12 AS=8.5e-12 PD=1.17e-05 PS=1.17e-05 NRD=0.0425 NRS=0.0425 $X=18150 $Y=35525 $D=37
M7 8 8 GNDA GNDA nmos4 L=1e-05 W=1e-05 AD=8.5e-12 AS=8.5e-12 PD=1.17e-05 PS=1.17e-05 NRD=0.0425 NRS=0.0425 $X=30450 $Y=22825 $D=37
M8 7 8 GNDA GNDA nmos4 L=1e-05 W=1e-05 AD=8.5e-12 AS=8.5e-12 PD=1.17e-05 PS=1.17e-05 NRD=0.0425 NRS=0.0425 $X=30450 $Y=35525 $D=37
M9 11 11 GNDA GNDA nmos4 L=8e-06 W=1e-05 AD=8.5e-12 AS=8.5e-12 PD=1.17e-05 PS=1.17e-05 NRD=0.0425 NRS=0.0425 $X=86475 $Y=22825 $D=37
M10 9 11 GNDA GNDA nmos4 L=8e-06 W=1e-05 AD=8.5e-12 AS=8.5e-12 PD=1.17e-05 PS=1.17e-05 NRD=0.0425 NRS=0.0425 $X=86475 $Y=35525 $D=37
M11 9 11 GNDA GNDA nmos4 L=8e-06 W=1e-05 AD=8.5e-12 AS=8.5e-12 PD=1.17e-05 PS=1.17e-05 NRD=0.0425 NRS=0.0425 $X=96775 $Y=22825 $D=37
M12 11 11 GNDA GNDA nmos4 L=8e-06 W=1e-05 AD=8.5e-12 AS=8.5e-12 PD=1.17e-05 PS=1.17e-05 NRD=0.0425 NRS=0.0425 $X=96775 $Y=35525 $D=37
M13 OUT 9 GNDA GNDA nmos4 L=2e-06 W=5e-06 AD=2.5e-12 AS=4.25e-12 PD=1e-06 PS=6.7e-06 NRD=0.085 NRS=0.085 $X=141600 $Y=21825 $D=37
M14 GNDA 9 OUT GNDA nmos4 L=2e-06 W=5e-06 AD=2.5e-12 AS=2.5e-12 PD=1e-06 PS=1e-06 NRD=0.085 NRS=0.085 $X=144600 $Y=21825 $D=37
M15 OUT 9 GNDA GNDA nmos4 L=2e-06 W=5e-06 AD=2.5e-12 AS=2.5e-12 PD=1e-06 PS=1e-06 NRD=0.085 NRS=0.085 $X=147600 $Y=21825 $D=37
M16 GNDA 9 OUT GNDA nmos4 L=2e-06 W=5e-06 AD=2.5e-12 AS=2.5e-12 PD=1e-06 PS=1e-06 NRD=0.085 NRS=0.085 $X=150600 $Y=21825 $D=37
M17 OUT 9 GNDA GNDA nmos4 L=2e-06 W=5e-06 AD=2.5e-12 AS=2.5e-12 PD=1e-06 PS=1e-06 NRD=0.085 NRS=0.085 $X=153600 $Y=21825 $D=37
M18 GNDA 9 OUT GNDA nmos4 L=2e-06 W=5e-06 AD=2.5e-12 AS=2.5e-12 PD=1e-06 PS=1e-06 NRD=0.085 NRS=0.085 $X=156600 $Y=21825 $D=37
M19 OUT 9 GNDA GNDA nmos4 L=2e-06 W=5e-06 AD=2.5e-12 AS=2.5e-12 PD=1e-06 PS=1e-06 NRD=0.085 NRS=0.085 $X=159600 $Y=21825 $D=37
M20 GNDA 9 OUT GNDA nmos4 L=2e-06 W=5e-06 AD=4.25e-12 AS=2.5e-12 PD=6.7e-06 PS=1e-06 NRD=0.085 NRS=0.085 $X=162600 $Y=21825 $D=37
M21 10 10 10 10 pmos4 L=5e-07 W=1.25e-05 AD=1.0625e-11 AS=1.0625e-11 PD=1.42e-05 PS=1.42e-05 NRD=0.034 NRS=0.034 $X=58325 $Y=73475 $D=42
M22 10 10 10 10 pmos4 L=5e-07 W=1.25e-05 AD=1.0625e-11 AS=1.0625e-11 PD=1.42e-05 PS=1.42e-05 NRD=0.034 NRS=0.034 $X=58325 $Y=93775 $D=42
M23 VDDA VDDA VDDA VDDA pmos4 L=3e-06 W=1e-05 AD=8.5e-12 AS=8.5e-12 PD=1.17e-05 PS=1.17e-05 NRD=0.0425 NRS=0.0425 $X=59150 $Y=136425 $D=42
M24 VDDA VDDA VDDA VDDA pmos4 L=3e-06 W=1e-05 AD=8.5e-12 AS=8.5e-12 PD=1.17e-05 PS=1.17e-05 NRD=0.0425 NRS=0.0425 $X=59150 $Y=151225 $D=42
M25 VDDA VDDA VDDA VDDA pmos4 L=3e-06 W=1e-05 AD=8.5e-12 AS=8.5e-12 PD=1.17e-05 PS=1.17e-05 NRD=0.0425 NRS=0.0425 $X=143950 $Y=136425 $D=42
M26 VDDA VDDA VDDA VDDA pmos4 L=3e-06 W=1e-05 AD=8.5e-12 AS=8.5e-12 PD=1.17e-05 PS=1.17e-05 NRD=0.0425 NRS=0.0425 $X=143950 $Y=151225 $D=42
M27 10 10 10 10 pmos4 L=5e-07 W=1.25e-05 AD=1.0625e-11 AS=1.0625e-11 PD=1.42e-05 PS=1.42e-05 NRD=0.034 NRS=0.034 $X=150725 $Y=73475 $D=42
M28 10 10 10 10 pmos4 L=5e-07 W=1.25e-05 AD=1.0625e-11 AS=1.0625e-11 PD=1.42e-05 PS=1.42e-05 NRD=0.034 NRS=0.034 $X=150725 $Y=93775 $D=42
M29 OUT 13 VDDA VDDA pmos4 L=3e-06 W=1e-05 AD=8.5e-12 AS=8.5e-12 PD=1.17e-05 PS=1.17e-05 NRD=0.0425 NRS=0.0425 $X=80350 $Y=136425 $D=41
M30 OUT 13 VDDA VDDA pmos4 L=3e-06 W=1e-05 AD=8.5e-12 AS=8.5e-12 PD=1.17e-05 PS=1.17e-05 NRD=0.0425 NRS=0.0425 $X=80350 $Y=151225 $D=41
M31 11 14 10 10 pmos4 L=5e-07 W=1.25e-05 AD=1.0625e-11 AS=1.0625e-11 PD=1.42e-05 PS=1.42e-05 NRD=0.034 NRS=0.034 $X=80725 $Y=73475 $D=41
M32 9 INP 10 10 pmos4 L=5e-07 W=1.25e-05 AD=1.0625e-11 AS=1.0625e-11 PD=1.42e-05 PS=1.42e-05 NRD=0.034 NRS=0.034 $X=80725 $Y=93775 $D=41
M33 13 13 VDDA VDDA pmos4 L=3e-06 W=1e-05 AD=8.5e-12 AS=8.5e-12 PD=1.17e-05 PS=1.17e-05 NRD=0.0425 NRS=0.0425 $X=101550 $Y=136425 $D=41
M34 OUT 13 VDDA VDDA pmos4 L=3e-06 W=1e-05 AD=8.5e-12 AS=8.5e-12 PD=1.17e-05 PS=1.17e-05 NRD=0.0425 NRS=0.0425 $X=101550 $Y=151225 $D=41
M35 11 14 10 10 pmos4 L=5e-07 W=1.25e-05 AD=1.0625e-11 AS=1.0625e-11 PD=1.42e-05 PS=1.42e-05 NRD=0.034 NRS=0.034 $X=103125 $Y=73475 $D=41
M36 9 INP 10 10 pmos4 L=5e-07 W=1.25e-05 AD=1.0625e-11 AS=1.0625e-11 PD=1.42e-05 PS=1.42e-05 NRD=0.034 NRS=0.034 $X=103125 $Y=93775 $D=41
M37 OUT 13 VDDA VDDA pmos4 L=3e-06 W=1e-05 AD=8.5e-12 AS=8.5e-12 PD=1.17e-05 PS=1.17e-05 NRD=0.0425 NRS=0.0425 $X=122750 $Y=136425 $D=41
M38 OUT 13 VDDA VDDA pmos4 L=3e-06 W=1e-05 AD=8.5e-12 AS=8.5e-12 PD=1.17e-05 PS=1.17e-05 NRD=0.0425 NRS=0.0425 $X=122750 $Y=151225 $D=41
M39 9 INP 10 10 pmos4 L=5e-07 W=1.25e-05 AD=1.0625e-11 AS=1.0625e-11 PD=1.42e-05 PS=1.42e-05 NRD=0.034 NRS=0.034 $X=125525 $Y=73475 $D=41
M40 11 14 10 10 pmos4 L=5e-07 W=1.25e-05 AD=1.0625e-11 AS=1.0625e-11 PD=1.42e-05 PS=1.42e-05 NRD=0.034 NRS=0.034 $X=125525 $Y=93775 $D=41
M41 9 INP 10 10 pmos4 L=5e-07 W=1.25e-05 AD=1.0625e-11 AS=1.0625e-11 PD=1.42e-05 PS=1.42e-05 NRD=0.034 NRS=0.034 $X=147925 $Y=73475 $D=41
M42 11 14 10 10 pmos4 L=5e-07 W=1.25e-05 AD=1.0625e-11 AS=1.0625e-11 PD=1.42e-05 PS=1.42e-05 NRD=0.034 NRS=0.034 $X=147925 $Y=93775 $D=41
C43 13 VDDA $[cpolya] $A=780 $P=112 $X=8300 $Y=137700 $D=58
C44 GNDA VDDA $[cpolya] $A=1715.7 $P=174.2 $X=168350 $Y=137000 $D=58
X51 8 BIAS BIAS GNDA nmos4_CDNS_7807366010386 $T=15500 75600 0 90 $X=6550 $Y=75200
X52 7 13 BIAS GNDA nmos4_CDNS_7807366010386 $T=24800 75600 0 90 $X=15850 $Y=75200
X57 VDDA OUT OUT OUT 13 ICV_76 $T=58300 146425 0 270 $X=57100 $Y=135225
X58 VDDA OUT OUT OUT 13 ICV_76 $T=58300 161225 0 270 $X=57100 $Y=150025
X59 VDDA OUT OUT 10 13 ICV_76 $T=79500 146425 0 270 $X=78300 $Y=135225
X60 VDDA OUT 10 OUT 13 ICV_76 $T=79500 161225 0 270 $X=78300 $Y=150025
X61 VDDA 10 OUT OUT 13 ICV_76 $T=100700 146425 0 270 $X=99500 $Y=135225
X62 VDDA OUT 10 OUT 13 ICV_76 $T=100700 161225 0 270 $X=99500 $Y=150025
X63 VDDA OUT OUT OUT 13 ICV_76 $T=121900 146425 0 270 $X=120700 $Y=135225
X64 VDDA OUT OUT OUT 13 ICV_76 $T=121900 161225 0 270 $X=120700 $Y=150025
X65 GNDA BIAS cpolyc_CDNS_78073660103112 $T=8600 131150 0 270 $X=7250 $Y=87000
X72 10 9 11 INP 14 ICV_108 $T=57475 85975 0 270 $X=56275 $Y=72275
X73 10 11 9 14 INP ICV_108 $T=57475 106275 0 270 $X=56275 $Y=92575
X74 10 9 11 INP 14 ICV_108 $T=79875 85975 0 270 $X=78675 $Y=72275
X75 10 11 9 14 INP ICV_108 $T=79875 106275 0 270 $X=78675 $Y=92575
X76 10 11 9 14 INP ICV_108 $T=102275 85975 0 270 $X=101075 $Y=72275
X77 10 9 11 INP 14 ICV_108 $T=102275 106275 0 270 $X=101075 $Y=92575
X78 10 11 9 14 INP ICV_108 $T=124675 85975 0 270 $X=123475 $Y=72275
X79 10 9 11 INP 14 ICV_108 $T=124675 106275 0 270 $X=123475 $Y=92575
X80 OUT 14 rpolyhc_CDNS_78073660103114 $T=196900 20150 0 90 $X=171550 $Y=13500
X81 14 CBUF rpolyhc_CDNS_78073660103114 $T=201800 95750 0 270 $X=197150 $Y=13500
X82 OUT 12 cpolyc_CDNS_78073660103110 $T=230350 19625 0 0 $X=229000 $Y=18275
X83 OUT 12 cpolyc_CDNS_78073660103110 $T=230350 56925 0 0 $X=229000 $Y=55575
X84 OUT 12 cpolyc_CDNS_78073660103110 $T=230350 94225 0 0 $X=229000 $Y=92875
X85 OUT 12 cpolyc_CDNS_78073660103110 $T=230350 131525 0 0 $X=229000 $Y=130175
X86 OUT 12 cpolyc_CDNS_78073660103110 $T=286450 19625 0 0 $X=285100 $Y=18275
X87 OUT 12 cpolyc_CDNS_78073660103110 $T=286450 56925 0 0 $X=285100 $Y=55575
X88 OUT 12 cpolyc_CDNS_78073660103110 $T=286450 94225 0 0 $X=285100 $Y=92875
X89 OUT 12 cpolyc_CDNS_78073660103110 $T=286450 131525 0 0 $X=285100 $Y=130175
.ENDS
***************************************
.SUBCKT fecg_front_end_f_3 VINN VINP F<0> F<1> F<2> VREF_CM CM EN_CMFB CLK EXC2 EXC1 BIAS7 BIAS2 VDDA BIAS1 CMFB VREF BIAS3 BIAS5 BIAS4
+ CVGA S<0> S<1> S<2> BIAS6 GNDA OUT CBUF GNDD VDDD
** N=52 EP=30 IP=115 FDC=2403
X0 VDDA GNDA V500_20 $T=16700 491100 1 270 $X=-7400 $Y=-3400
X1 VDDA GNDA V500_20 $T=83650 249550 1 0 $X=83450 $Y=225450
X2 VDDA GNDA V500_20 $T=420050 493850 1 0 $X=419850 $Y=469750
X3 VDDA GNDA V500_20 $T=429550 741350 1 0 $X=429350 $Y=717250
X4 VDDA GNDA V500_20 $T=1017375 493850 1 0 $X=1017175 $Y=469750
X5 VDDA GNDA V500_20 $T=1019550 249600 1 0 $X=1019350 $Y=225500
X6 VDDA GNDA V500_20 $T=1021750 741400 1 0 $X=1021550 $Y=717300
X7 VDDA GNDA V500_20 $T=1039100 5100 1 0 $X=1038900 $Y=-19000
X8 VDDA GNDA V500_20 $T=1920200 723850 0 270 $X=1920150 $Y=229350
X9 35 34 CLK EXC1 EXC2 VINN VINP 38 51 BIAS1 40 VDDA 50 48 GNDA 52 39 37 47 36
+ 41 42 VREF GNDD VDDD
+ fecg_ia_5_fc $T=-33100 462600 0 0 $X=17400 $Y=497200
X10 BIAS2 VDDA 41 32 43 F<2> F<1> F<0> GNDA gmc_5_fc $T=19200 249850 0 0 $X=19600 $Y=250250
X11 BIAS3 VDDA 43 32 32 F<2> F<1> F<0> GNDA gmc_5_fc $T=666150 5600 0 0 $X=666550 $Y=6000
X12 BIAS5 VDDA 44 33 33 F<2> F<1> F<0> GNDA gmc_5_fc $T=971475 497425 0 0 $X=971875 $Y=497825
X13 CM VREF_CM EN_CMFB BIAS7 VDDA GNDA VINP VINN CMFB 49 fecg_cmfb2_fc $T=17500 11000 0 0 $X=25750 $Y=16848
X14 VDDA GNDA V1000_20 $T=39100 5100 1 0 $X=38900 $Y=-19000
X15 VDDA GNDA V200_20 $T=617650 213925 0 270 $X=617600 $Y=13875
X16 VDDA GNDA V200_20 $T=946250 702525 0 270 $X=946200 $Y=502475
X17 VDDA GNDA V200_20 $T=950150 464100 0 270 $X=950100 $Y=264050
X18 VDDA GNDA V200_20 $T=1521750 741350 1 0 $X=1521800 $Y=717300
X19 VDDA GNDA V200_20 $T=1596900 217600 0 270 $X=1596850 $Y=17550
X20 44 45 46 VDDA BIAS4 GNDA CVGA S<0> S<1> S<2> 32 fecg_vga2_f_2 $T=977600 249550 0 0 $X=977075 $Y=252948
X21 BIAS6 GNDA OUT 33 VDDA CBUF buffer2_f_3c $T=1576550 275625 0 0 $X=1578850 $Y=279298
.ENDS
***************************************
.SUBCKT FILLCAPX8 gnd! vdd!
** N=4 EP=2 IP=0 FDC=2
M0 4 3 gnd! gnd! nmos4 L=1.25e-06 W=9.8e-06 AD=8.33e-12 AS=8.33e-12 PD=1.15e-05 PS=1.15e-05 NRD=0.0433673 NRS=0.0433673 $X=775 $Y=1900 $D=37
M1 vdd! 4 3 vdd! pmos4 L=8.9e-06 W=2.85e-06 AD=2.4225e-12 AS=2.4225e-12 PD=4.55e-06 PS=4.55e-06 NRD=0.149123 NRS=0.149123 $X=1150 $Y=6400 $D=41
.ENDS
***************************************
.SUBCKT FILLCAPX4 gnd! vdd!
** N=4 EP=2 IP=0 FDC=2
M0 4 3 gnd! gnd! nmos4 L=1.25e-06 W=4.2e-06 AD=3.57e-12 AS=3.57e-12 PD=5.9e-06 PS=5.9e-06 NRD=0.10119 NRS=0.10119 $X=775 $Y=1900 $D=37
M1 vdd! 4 3 vdd! pmos4 L=3.3e-06 W=2.85e-06 AD=2.4225e-12 AS=2.4225e-12 PD=4.55e-06 PS=4.55e-06 NRD=0.149123 NRS=0.149123 $X=1150 $Y=6400 $D=41
.ENDS
***************************************
.SUBCKT ICV_100 1 2
*.CALIBRE ICV_CELL 9
** N=2 EP=2 IP=4 FDC=4
X0 1 2 FILLCAPX8 $T=0 0 0 0 $X=-900 $Y=-1350
X1 1 2 FILLCAPX4 $T=11200 0 0 0 $X=10300 $Y=-1350
.ENDS
***************************************
.SUBCKT FILLCAPX2 gnd! vdd!
** N=4 EP=2 IP=0 FDC=2
M0 4 3 gnd! gnd! nmos4 L=5e-07 W=2.85e-06 AD=2.4225e-12 AS=2.4225e-12 PD=4.55e-06 PS=4.55e-06 NRD=0.149123 NRS=0.149123 $X=1150 $Y=1150 $D=37
M1 vdd! 4 3 vdd! pmos4 L=5e-07 W=2.85e-06 AD=2.4225e-12 AS=2.4225e-12 PD=4.55e-06 PS=4.55e-06 NRD=0.149123 NRS=0.149123 $X=1150 $Y=6400 $D=41
.ENDS
***************************************
.SUBCKT FILLCAPX32 gnd! vdd!
** N=4 EP=2 IP=0 FDC=2
M0 4 3 gnd! gnd! nmos4 L=1.25e-06 W=4.34e-05 AD=3.689e-11 AS=3.689e-11 PD=4.51e-05 PS=4.51e-05 NRD=0.00979263 NRS=0.00979263 $X=775 $Y=1900 $D=37
M1 vdd! 4 3 vdd! pmos4 L=4.25e-05 W=2.85e-06 AD=2.4225e-12 AS=2.4225e-12 PD=4.55e-06 PS=4.55e-06 NRD=0.149123 NRS=0.149123 $X=1150 $Y=6400 $D=41
.ENDS
***************************************
.SUBCKT FILLCAPX16 gnd! vdd!
** N=4 EP=2 IP=0 FDC=2
M0 4 3 gnd! gnd! nmos4 L=1.25e-06 W=2.1e-05 AD=1.785e-11 AS=1.785e-11 PD=2.27e-05 PS=2.27e-05 NRD=0.0202381 NRS=0.0202381 $X=775 $Y=1900 $D=37
M1 vdd! 4 3 vdd! pmos4 L=2.01e-05 W=2.85e-06 AD=2.4225e-12 AS=2.4225e-12 PD=4.55e-06 PS=4.55e-06 NRD=0.149123 NRS=0.149123 $X=1150 $Y=6400 $D=41
.ENDS
***************************************
.SUBCKT ICV_105 1 2
*.CALIBRE ICV_CELL 9
** N=2 EP=2 IP=4 FDC=4
X0 1 2 FILLCAPX32 $T=0 0 0 0 $X=-900 $Y=-1350
X1 1 2 FILLCAPX16 $T=44800 0 0 0 $X=43900 $Y=-1350
.ENDS
***************************************
.SUBCKT FILLCELLX2
** N=2 EP=0 IP=0 FDC=0
.ENDS
***************************************
.SUBCKT FILLCELLX1
** N=2 EP=0 IP=0 FDC=0
.ENDS
***************************************
.SUBCKT ICV_95
** N=2 EP=0 IP=4 FDC=0
.ENDS
***************************************
.SUBCKT DFCSX4 SE SI D CP RN Q gnd! vdd!
** N=26 EP=8 IP=0 FDC=38
M0 gnd! SE 9 gnd! nmos4 L=3.5e-07 W=5e-07 AD=4.625e-13 AS=5.9e-13 PD=1.75e-06 PS=2.7e-06 NRD=0.85 NRS=0.85 $X=1550 $Y=1800 $D=37
M1 22 SI gnd! gnd! nmos4 L=3.5e-07 W=5e-07 AD=1.125e-13 AS=4.625e-13 PD=4.5e-07 PS=1.75e-06 NRD=0.85 NRS=0.85 $X=3000 $Y=2000 $D=37
M2 14 SE 22 gnd! nmos4 L=3.5e-07 W=5e-07 AD=3.45e-13 AS=1.125e-13 PD=1.3e-06 PS=4.5e-07 NRD=0.85 NRS=0.85 $X=3800 $Y=2000 $D=37
M3 10 9 14 gnd! nmos4 L=3.5e-07 W=5e-07 AD=7.7e-13 AS=3.45e-13 PD=2.7e-06 PS=1.3e-06 NRD=0.85 NRS=0.85 $X=5250 $Y=2000 $D=37
M4 gnd! D 10 gnd! nmos4 L=3.5e-07 W=5e-07 AD=7.7e-13 AS=7.7e-13 PD=3.9e-06 PS=2.7e-06 NRD=0.85 NRS=0.85 $X=7350 $Y=2000 $D=37
M5 gnd! CP 11 gnd! nmos4 L=3.5e-07 W=5e-07 AD=6.3e-13 AS=5.9e-13 PD=3.2e-06 PS=2.7e-06 NRD=0.85 NRS=0.85 $X=9400 $Y=3300 $D=37
M6 12 11 gnd! gnd! nmos4 L=3.5e-07 W=5e-07 AD=6.9e-13 AS=6.3e-13 PD=3.1e-06 PS=3.2e-06 NRD=0.85 NRS=0.85 $X=10450 $Y=3300 $D=37
M7 16 11 14 gnd! nmos4 L=3.5e-07 W=5e-07 AD=3.7625e-13 AS=1.15e-12 PD=1.425e-06 PS=4.3e-06 NRD=0.85 NRS=0.85 $X=13400 $Y=2500 $D=37
M8 23 12 16 gnd! nmos4 L=3.5e-07 W=5e-07 AD=2.25e-13 AS=3.7625e-13 PD=9e-07 PS=1.425e-06 NRD=0.85 NRS=0.85 $X=14975 $Y=2500 $D=37
M9 24 17 23 gnd! nmos4 L=3.5e-07 W=5e-07 AD=1.125e-13 AS=2.25e-13 PD=4.5e-07 PS=9e-07 NRD=0.85 NRS=0.85 $X=16225 $Y=2500 $D=37
M10 gnd! RN 24 gnd! nmos4 L=3.5e-07 W=5e-07 AD=6.25e-13 AS=1.125e-13 PD=2.1e-06 PS=4.5e-07 NRD=0.85 NRS=0.85 $X=17025 $Y=2500 $D=37
M11 17 16 gnd! gnd! nmos4 L=3.5e-07 W=5e-07 AD=5.6625e-13 AS=6.25e-13 PD=2.4e-06 PS=2.1e-06 NRD=0.85 NRS=0.85 $X=18475 $Y=2500 $D=37
M12 19 12 17 gnd! nmos4 L=3.5e-07 W=5e-07 AD=8.1625e-13 AS=5.6625e-13 PD=3.025e-06 PS=2.4e-06 NRD=0.85 NRS=0.85 $X=20775 $Y=2650 $D=37
M13 20 11 19 gnd! nmos4 L=3.5e-07 W=5e-07 AD=3.44375e-13 AS=8.1625e-13 PD=1.3e-06 PS=3.025e-06 NRD=0.85 NRS=0.85 $X=23550 $Y=3250 $D=37
M14 gnd! 18 20 gnd! nmos4 L=3.5e-07 W=5e-07 AD=6.225e-13 AS=3.44375e-13 PD=3.15e-06 PS=1.3e-06 NRD=0.85 NRS=0.85 $X=25000 $Y=3300 $D=37
M15 25 RN gnd! gnd! nmos4 L=3.5e-07 W=5e-07 AD=1.75e-13 AS=6.225e-13 PD=7e-07 PS=3.15e-06 NRD=0.85 NRS=0.85 $X=26050 $Y=3300 $D=37
M16 18 19 25 gnd! nmos4 L=3.5e-07 W=5e-07 AD=5.9e-13 AS=1.75e-13 PD=2.7e-06 PS=7e-07 NRD=0.85 NRS=0.85 $X=27100 $Y=3300 $D=37
M17 gnd! 18 Q gnd! nmos4 L=3.5e-07 W=1.6e-06 AD=8e-13 AS=1.36e-12 PD=1e-06 PS=3.3e-06 NRD=0.265625 NRS=0.265625 $X=31850 $Y=2400 $D=37
M18 QN 20 gnd! gnd! nmos4 L=3.5e-07 W=1.6e-06 AD=1.36e-12 AS=8e-13 PD=3.3e-06 PS=1e-06 NRD=0.265625 NRS=0.265625 $X=33200 $Y=2400 $D=37
M19 vdd! SE 9 vdd! pmos4 L=3.5e-07 W=1.05e-06 AD=5.25e-13 AS=1.60125e-12 PD=1e-06 PS=4.1e-06 NRD=0.404762 NRS=0.404762 $X=2050 $Y=6400 $D=41
M20 26 SI vdd! vdd! pmos4 L=3.5e-07 W=1.05e-06 AD=2.3625e-13 AS=5.25e-13 PD=4.5e-07 PS=1e-06 NRD=0.404762 NRS=0.404762 $X=3400 $Y=6400 $D=41
M21 13 9 26 vdd! pmos4 L=3.5e-07 W=1.05e-06 AD=5.25e-13 AS=2.3625e-13 PD=1e-06 PS=4.5e-07 NRD=0.404762 NRS=0.404762 $X=4200 $Y=6400 $D=41
M22 10 SE 13 vdd! pmos4 L=3.5e-07 W=1.05e-06 AD=5.25e-13 AS=5.25e-13 PD=1e-06 PS=1e-06 NRD=0.404762 NRS=0.404762 $X=5550 $Y=6400 $D=41
M23 vdd! D 10 vdd! pmos4 L=3.5e-07 W=1.05e-06 AD=1.33e-12 AS=5.25e-13 PD=6.35e-06 PS=1e-06 NRD=0.404762 NRS=0.404762 $X=6900 $Y=6400 $D=41
M24 vdd! CP 11 vdd! pmos4 L=3.5e-07 W=1.05e-06 AD=7.7e-13 AS=8.925e-13 PD=2.85e-06 PS=2.75e-06 NRD=0.404762 NRS=0.404762 $X=9400 $Y=6400 $D=41
M25 12 11 vdd! vdd! pmos4 L=3.5e-07 W=1.05e-06 AD=8.925e-13 AS=7.7e-13 PD=2.75e-06 PS=2.85e-06 NRD=0.404762 NRS=0.404762 $X=10450 $Y=6400 $D=41
M26 16 12 13 vdd! pmos4 L=3.5e-07 W=1.05e-06 AD=5.25e-13 AS=8.925e-13 PD=1e-06 PS=2.75e-06 NRD=0.404762 NRS=0.404762 $X=13100 $Y=7100 $D=41
M27 15 11 16 vdd! pmos4 L=3.5e-07 W=1.05e-06 AD=5.25e-13 AS=5.25e-13 PD=1e-06 PS=1e-06 NRD=0.404762 NRS=0.404762 $X=14450 $Y=7100 $D=41
M28 vdd! 17 15 vdd! pmos4 L=3.5e-07 W=1.05e-06 AD=5.25e-13 AS=5.25e-13 PD=1e-06 PS=1e-06 NRD=0.404762 NRS=0.404762 $X=15800 $Y=7100 $D=41
M29 15 RN vdd! vdd! pmos4 L=3.5e-07 W=1.05e-06 AD=8.925e-13 AS=5.25e-13 PD=2.75e-06 PS=1e-06 NRD=0.404762 NRS=0.404762 $X=17150 $Y=7100 $D=41
M30 17 16 vdd! vdd! pmos4 L=3.5e-07 W=1.05e-06 AD=5.25e-13 AS=8.925e-13 PD=1e-06 PS=2.75e-06 NRD=0.404762 NRS=0.404762 $X=20200 $Y=6400 $D=41
M31 19 11 17 vdd! pmos4 L=3.5e-07 W=1.05e-06 AD=5.25e-13 AS=5.25e-13 PD=1e-06 PS=1e-06 NRD=0.404762 NRS=0.404762 $X=21550 $Y=6400 $D=41
M32 20 12 19 vdd! pmos4 L=3.5e-07 W=1.05e-06 AD=1.05e-12 AS=5.25e-13 PD=2e-06 PS=1e-06 NRD=0.404762 NRS=0.404762 $X=22900 $Y=6400 $D=41
M33 vdd! 18 20 vdd! pmos4 L=3.5e-07 W=1.05e-06 AD=7.7e-13 AS=1.05e-12 PD=2.85e-06 PS=2e-06 NRD=0.404762 NRS=0.404762 $X=25250 $Y=6400 $D=41
M34 18 RN vdd! vdd! pmos4 L=3.5e-07 W=1.05e-06 AD=8.925e-13 AS=7.7e-13 PD=1.7e-06 PS=2.85e-06 NRD=0.404762 NRS=0.404762 $X=26300 $Y=6400 $D=41
M35 vdd! 19 18 vdd! pmos4 L=3.5e-07 W=1.05e-06 AD=9.45e-13 AS=8.925e-13 PD=2.85e-06 PS=1.7e-06 NRD=0.404762 NRS=0.404762 $X=28350 $Y=6400 $D=41
M36 vdd! 18 Q vdd! pmos4 L=3.5e-07 W=2.775e-06 AD=1.3875e-12 AS=2.35875e-12 PD=1e-06 PS=4.475e-06 NRD=0.153153 NRS=0.153153 $X=31850 $Y=6400 $D=41
M37 QN 20 vdd! vdd! pmos4 L=3.5e-07 W=2.775e-06 AD=2.35875e-12 AS=1.3875e-12 PD=4.475e-06 PS=1e-06 NRD=0.153153 NRS=0.153153 $X=33200 $Y=6400 $D=41
.ENDS
***************************************
.SUBCKT ICV_103 1 2 3 4 5 6 7 8
*.CALIBRE ICV_CELL 9
** N=8 EP=8 IP=10 FDC=38
X1 3 4 5 6 7 8 1 2 DFCSX4 $T=4200 0 0 0 $X=3350 $Y=-1350
.ENDS
***************************************
.SUBCKT FILLCELLX4
** N=2 EP=0 IP=0 FDC=0
.ENDS
***************************************
.SUBCKT FILLCELLX8
** N=2 EP=0 IP=0 FDC=0
.ENDS
***************************************
.SUBCKT CLKBUFX16 A gnd! Q vdd!
** N=5 EP=4 IP=0 FDC=10
M0 gnd! A 5 gnd! nmos4 L=3.5e-07 W=1.775e-06 AD=8.875e-13 AS=1.50875e-12 PD=1.06955e-06 PS=3.475e-06 NRD=0.239437 NRS=0.239437 $X=2700 $Y=1875 $D=37
M1 Q 5 gnd! gnd! nmos4 L=3.5e-07 W=2.125e-06 AD=1.0625e-12 AS=1.0625e-12 PD=1e-06 PS=1.28045e-06 NRD=0.2 NRS=0.2 $X=4050 $Y=1875 $D=37
M2 gnd! 5 Q gnd! nmos4 L=3.5e-07 W=2.125e-06 AD=1.0625e-12 AS=1.0625e-12 PD=1e-06 PS=1e-06 NRD=0.2 NRS=0.2 $X=5400 $Y=1875 $D=37
M3 Q 5 gnd! gnd! nmos4 L=3.5e-07 W=2.125e-06 AD=1.5875e-12 AS=1.0625e-12 PD=3.825e-06 PS=1e-06 NRD=0.2 NRS=0.2 $X=6750 $Y=1875 $D=37
M4 5 A vdd! vdd! pmos4 L=3.5e-07 W=1.55e-06 AD=7.75e-13 AS=1.3175e-12 PD=1e-06 PS=3.25e-06 NRD=0.274194 NRS=0.274194 $X=1350 $Y=7650 $D=41
M5 vdd! A 5 vdd! pmos4 L=3.5e-07 W=1.55e-06 AD=7.75e-13 AS=7.75e-13 PD=1.15805e-06 PS=1e-06 NRD=0.274194 NRS=0.274194 $X=2700 $Y=7650 $D=41
M6 Q 5 vdd! vdd! pmos4 L=3.5e-07 W=2.8e-06 AD=1.4e-12 AS=1.4e-12 PD=1e-06 PS=2.09195e-06 NRD=0.151786 NRS=0.151786 $X=4050 $Y=6400 $D=41
M7 vdd! 5 Q vdd! pmos4 L=3.5e-07 W=2.8e-06 AD=1.4e-12 AS=1.4e-12 PD=1e-06 PS=1e-06 NRD=0.151786 NRS=0.151786 $X=5400 $Y=6400 $D=41
M8 Q 5 vdd! vdd! pmos4 L=3.5e-07 W=2.8e-06 AD=1.4e-12 AS=1.4e-12 PD=1e-06 PS=1e-06 NRD=0.151786 NRS=0.151786 $X=6750 $Y=6400 $D=41
M9 vdd! 5 Q vdd! pmos4 L=3.5e-07 W=2.8e-06 AD=1.925e-12 AS=1.4e-12 PD=4.5e-06 PS=1e-06 NRD=0.151786 NRS=0.151786 $X=8100 $Y=6400 $D=41
.ENDS
***************************************
.SUBCKT ICV_97 1 2
*.CALIBRE ICV_CELL 9
** N=2 EP=2 IP=4 FDC=4
X0 1 2 FILLCAPX4 $T=0 0 0 0 $X=-900 $Y=-1350
X1 1 2 FILLCAPX2 $T=5600 0 0 0 $X=4700 $Y=-1350
.ENDS
***************************************
.SUBCKT ICV_98 1 2
*.CALIBRE ICV_CELL 9
** N=2 EP=2 IP=4 FDC=4
X0 1 2 FILLCAPX8 $T=0 0 0 0 $X=-900 $Y=-1350
X1 1 2 FILLCAPX2 $T=11200 0 0 0 $X=10300 $Y=-1350
.ENDS
***************************************
.SUBCKT DFCX4 CP D RN Q gnd! vdd! QN
** N=20 EP=7 IP=0 FDC=30
M0 gnd! CP 11 gnd! nmos4 L=3.5e-07 W=5e-07 AD=5.9875e-13 AS=5.9e-13 PD=2.025e-06 PS=2.7e-06 NRD=0.85 NRS=0.85 $X=1625 $Y=2300 $D=37
M1 12 11 gnd! gnd! nmos4 L=3.5e-07 W=5e-07 AD=1.15e-12 AS=5.9875e-13 PD=4.3e-06 PS=2.025e-06 NRD=0.85 NRS=0.85 $X=3075 $Y=2300 $D=37
M2 16 11 gnd! gnd! nmos4 L=3.5e-07 W=5e-07 AD=2e-13 AS=1.15e-12 PD=8e-07 PS=4.3e-06 NRD=0.85 NRS=0.85 $X=6050 $Y=2750 $D=37
M3 8 D 16 gnd! nmos4 L=3.5e-07 W=5e-07 AD=6.58125e-13 AS=2e-13 PD=2.625e-06 PS=8e-07 NRD=0.85 NRS=0.85 $X=7200 $Y=2750 $D=37
M4 17 12 8 gnd! nmos4 L=3.5e-07 W=5e-07 AD=1.125e-13 AS=6.58125e-13 PD=4.5e-07 PS=2.625e-06 NRD=0.85 NRS=0.85 $X=9775 $Y=2800 $D=37
M5 18 10 17 gnd! nmos4 L=3.5e-07 W=5e-07 AD=1.125e-13 AS=1.125e-13 PD=4.5e-07 PS=4.5e-07 NRD=0.85 NRS=0.85 $X=10575 $Y=2800 $D=37
M6 gnd! RN 18 gnd! nmos4 L=3.5e-07 W=5e-07 AD=7.65e-13 AS=1.125e-13 PD=2.5e-06 PS=4.5e-07 NRD=0.85 NRS=0.85 $X=11375 $Y=2800 $D=37
M7 10 8 gnd! gnd! nmos4 L=3.5e-07 W=5e-07 AD=5.575e-13 AS=7.65e-13 PD=2.15e-06 PS=2.5e-06 NRD=0.85 NRS=0.85 $X=12825 $Y=2800 $D=37
M8 13 12 10 gnd! nmos4 L=3.5e-07 W=5e-07 AD=7.375e-13 AS=5.575e-13 PD=2.55e-06 PS=2.15e-06 NRD=0.85 NRS=0.85 $X=15125 $Y=2800 $D=37
M9 15 11 13 gnd! nmos4 L=3.5e-07 W=5e-07 AD=5.8875e-13 AS=7.375e-13 PD=2.7e-06 PS=2.55e-06 NRD=0.85 NRS=0.85 $X=17025 $Y=2800 $D=37
M10 gnd! 14 15 gnd! nmos4 L=3.5e-07 W=5e-07 AD=9.625e-13 AS=5.9e-13 PD=3.25e-06 PS=2.7e-06 NRD=0.85 NRS=0.85 $X=19775 $Y=2750 $D=37
M11 19 RN gnd! gnd! nmos4 L=3.5e-07 W=5e-07 AD=1.125e-13 AS=9.625e-13 PD=4.5e-07 PS=3.25e-06 NRD=0.85 NRS=0.85 $X=21875 $Y=2750 $D=37
M12 14 13 19 gnd! nmos4 L=3.5e-07 W=5e-07 AD=7.3e-13 AS=1.125e-13 PD=3.1e-06 PS=4.5e-07 NRD=0.85 NRS=0.85 $X=22675 $Y=2750 $D=37
M13 gnd! 14 Q gnd! nmos4 L=3.5e-07 W=1.6e-06 AD=8e-13 AS=1.36e-12 PD=1e-06 PS=3.3e-06 NRD=0.265625 NRS=0.265625 $X=26500 $Y=2400 $D=37
M14 QN 15 gnd! gnd! nmos4 L=3.5e-07 W=1.6e-06 AD=1.36e-12 AS=8e-13 PD=3.3e-06 PS=1e-06 NRD=0.265625 NRS=0.265625 $X=27850 $Y=2400 $D=37
M15 vdd! CP 11 vdd! pmos4 L=3.5e-07 W=1.05e-06 AD=5.5125e-13 AS=8.925e-13 PD=1.05e-06 PS=2.75e-06 NRD=0.404762 NRS=0.404762 $X=1200 $Y=6400 $D=41
M16 12 11 vdd! vdd! pmos4 L=3.5e-07 W=1.05e-06 AD=1.6275e-12 AS=5.5125e-13 PD=4.15e-06 PS=1.05e-06 NRD=0.404762 NRS=0.404762 $X=2600 $Y=6400 $D=41
M17 20 12 vdd! vdd! pmos4 L=3.5e-07 W=1.05e-06 AD=2.3625e-13 AS=8.925e-13 PD=4.5e-07 PS=2.75e-06 NRD=0.404762 NRS=0.404762 $X=6750 $Y=6400 $D=41
M18 8 D 20 vdd! pmos4 L=3.5e-07 W=1.05e-06 AD=5.25e-13 AS=2.3625e-13 PD=1e-06 PS=4.5e-07 NRD=0.404762 NRS=0.404762 $X=7550 $Y=6400 $D=41
M19 9 11 8 vdd! pmos4 L=3.5e-07 W=1.05e-06 AD=5.25e-13 AS=5.25e-13 PD=1e-06 PS=1e-06 NRD=0.404762 NRS=0.404762 $X=8900 $Y=6400 $D=41
M20 vdd! 10 9 vdd! pmos4 L=3.5e-07 W=1.05e-06 AD=1.33e-12 AS=5.25e-13 PD=6.35e-06 PS=1e-06 NRD=0.404762 NRS=0.404762 $X=10250 $Y=6400 $D=41
M21 vdd! RN 9 vdd! pmos4 L=3.5e-07 W=1.05e-06 AD=7.7e-13 AS=7.7e-13 PD=2.85e-06 PS=2.75e-06 NRD=0.404762 NRS=0.404762 $X=12550 $Y=6400 $D=41
M22 10 8 vdd! vdd! pmos4 L=3.5e-07 W=1.05e-06 AD=8.26875e-13 AS=7.7e-13 PD=2.075e-06 PS=2.85e-06 NRD=0.404762 NRS=0.404762 $X=13600 $Y=6400 $D=41
M23 13 11 10 vdd! pmos4 L=3.5e-07 W=1.05e-06 AD=5.5125e-13 AS=8.26875e-13 PD=1.05e-06 PS=2.075e-06 NRD=0.404762 NRS=0.404762 $X=15650 $Y=6775 $D=41
M24 15 12 13 vdd! pmos4 L=3.5e-07 W=1.05e-06 AD=1.07625e-12 AS=5.5125e-13 PD=2.05e-06 PS=1.05e-06 NRD=0.404762 NRS=0.404762 $X=17050 $Y=6775 $D=41
M25 vdd! 14 15 vdd! pmos4 L=3.5e-07 W=1.05e-06 AD=8.525e-13 AS=1.07625e-12 PD=3.025e-06 PS=2.05e-06 NRD=0.404762 NRS=0.404762 $X=19450 $Y=6775 $D=41
M26 14 RN vdd! vdd! pmos4 L=3.5e-07 W=1.05e-06 AD=8.26875e-13 AS=8.525e-13 PD=1.575e-06 PS=3.025e-06 NRD=0.404762 NRS=0.404762 $X=20750 $Y=6475 $D=41
M27 vdd! 13 14 vdd! pmos4 L=3.5e-07 W=1.05e-06 AD=1.07625e-12 AS=8.26875e-13 PD=3.1e-06 PS=1.575e-06 NRD=0.404762 NRS=0.404762 $X=22675 $Y=6475 $D=41
M28 vdd! 14 Q vdd! pmos4 L=3.5e-07 W=2.8e-06 AD=1.4e-12 AS=1.7675e-12 PD=1e-06 PS=4.5e-06 NRD=0.151786 NRS=0.151786 $X=26500 $Y=6400 $D=41
M29 QN 15 vdd! vdd! pmos4 L=3.5e-07 W=2.8e-06 AD=1.925e-12 AS=1.4e-12 PD=4.5e-06 PS=1e-06 NRD=0.151786 NRS=0.151786 $X=27850 $Y=6400 $D=41
.ENDS
***************************************
.SUBCKT ICV_96 1 2
*.CALIBRE ICV_CELL 9
** N=2 EP=2 IP=4 FDC=2
X0 1 2 FILLCAPX2 $T=0 0 0 0 $X=-900 $Y=-1350
.ENDS
***************************************
.SUBCKT CLKBUFX4 A vdd! gnd! Q
** N=5 EP=4 IP=0 FDC=4
M0 gnd! A 5 gnd! nmos4 L=3.5e-07 W=4.5e-07 AD=3.1061e-13 AS=1.14e-12 PD=7.13415e-07 PS=4.35e-06 NRD=0.944444 NRS=0.944444 $X=1200 $Y=2500 $D=37
M1 Q 5 gnd! gnd! nmos4 L=3.5e-07 W=1.6e-06 AD=1.045e-12 AS=1.10439e-12 PD=3.3e-06 PS=2.53659e-06 NRD=0.265625 NRS=0.265625 $X=2600 $Y=1450 $D=37
M2 vdd! A 5 vdd! pmos4 L=3.5e-07 W=7.75e-07 AD=3.9021e-13 AS=6.5875e-13 PD=8.94231e-07 PS=2.475e-06 NRD=0.548387 NRS=0.548387 $X=1500 $Y=6400 $D=41
M3 Q 5 vdd! vdd! pmos4 L=3.5e-07 W=2.8e-06 AD=1.925e-12 AS=1.40979e-12 PD=4.5e-06 PS=3.23077e-06 NRD=0.151786 NRS=0.151786 $X=2550 $Y=6400 $D=41
.ENDS
***************************************
.SUBCKT ICV_99 1 2 3 4
*.CALIBRE ICV_CELL 9
** N=4 EP=4 IP=6 FDC=4
X1 3 2 1 4 CLKBUFX4 $T=0 0 0 0 $X=-850 $Y=-1350
.ENDS
***************************************
.SUBCKT ICV_104 1 2 3 4 5 6 7 8 9 10
*.CALIBRE ICV_CELL 9
** N=10 EP=10 IP=12 FDC=42
X0 3 4 5 6 7 8 1 2 DFCSX4 $T=4200 0 0 0 $X=3350 $Y=-1350
X1 9 2 1 10 CLKBUFX4 $T=0 0 0 0 $X=-850 $Y=-1350
.ENDS
***************************************
.SUBCKT NOR2X3 B vdd! Q A gnd!
** N=6 EP=5 IP=0 FDC=4
M0 Q B gnd! gnd! nmos4 L=3.5e-07 W=1.2e-06 AD=6e-13 AS=8.45e-13 PD=1e-06 PS=2.9e-06 NRD=0.354167 NRS=0.354167 $X=1200 $Y=2300 $D=37
M1 gnd! A Q gnd! nmos4 L=3.5e-07 W=1.2e-06 AD=8.45e-13 AS=6e-13 PD=2.9e-06 PS=1e-06 NRD=0.354167 NRS=0.354167 $X=2550 $Y=2300 $D=37
M2 6 B vdd! vdd! pmos4 L=3.5e-07 W=2.35e-06 AD=5.2875e-13 AS=1.7e-12 PD=4.5e-07 PS=4.05e-06 NRD=0.180851 NRS=0.180851 $X=1200 $Y=6400 $D=41
M3 Q A 6 vdd! pmos4 L=3.5e-07 W=2.35e-06 AD=1.7e-12 AS=5.2875e-13 PD=4.05e-06 PS=4.5e-07 NRD=0.180851 NRS=0.180851 $X=2000 $Y=6400 $D=41
.ENDS
***************************************
.SUBCKT AND2X4 A B gnd! vdd! Q
** N=7 EP=5 IP=0 FDC=6
M0 7 A 6 gnd! nmos4 L=3.5e-07 W=9e-07 AD=2.025e-13 AS=7.65e-13 PD=4.5e-07 PS=2.6e-06 NRD=0.472222 NRS=0.472222 $X=1250 $Y=1600 $D=37
M1 gnd! B 7 gnd! nmos4 L=3.5e-07 W=9e-07 AD=4.5e-13 AS=2.025e-13 PD=9.72e-07 PS=4.5e-07 NRD=0.472222 NRS=0.472222 $X=2050 $Y=1600 $D=37
M2 Q 6 gnd! gnd! nmos4 L=3.5e-07 W=1.6e-06 AD=1.045e-12 AS=8e-13 PD=3.3e-06 PS=1.728e-06 NRD=0.265625 NRS=0.265625 $X=3400 $Y=1600 $D=37
M3 6 A vdd! vdd! pmos4 L=3.5e-07 W=1.425e-06 AD=7.125e-13 AS=9.575e-13 PD=1e-06 PS=3.125e-06 NRD=0.298246 NRS=0.298246 $X=1200 $Y=6400 $D=41
M4 vdd! B 6 vdd! pmos4 L=3.5e-07 W=1.425e-06 AD=6.50947e-13 AS=7.125e-13 PD=1.17204e-06 PS=1e-06 NRD=0.298246 NRS=0.298246 $X=2550 $Y=6400 $D=41
M5 Q 6 vdd! vdd! pmos4 L=3.5e-07 W=2.8e-06 AD=1.925e-12 AS=1.27905e-12 PD=4.5e-06 PS=2.30296e-06 NRD=0.151786 NRS=0.151786 $X=3600 $Y=6400 $D=41
.ENDS
***************************************
.SUBCKT CLKBUFX2 A vdd! gnd! Q
** N=5 EP=4 IP=0 FDC=4
M0 gnd! A 5 gnd! nmos4 L=3.5e-07 W=4e-07 AD=3.83333e-13 AS=5.7e-13 PD=1.73333e-06 PS=2.8e-06 NRD=1.0625 NRS=1.0625 $X=1450 $Y=2600 $D=37
M1 Q 5 gnd! gnd! nmos4 L=3.5e-07 W=8e-07 AD=6.8e-13 AS=7.66667e-13 PD=2.5e-06 PS=3.46667e-06 NRD=0.53125 NRS=0.53125 $X=2500 $Y=2650 $D=37
M2 vdd! A 5 vdd! pmos4 L=3.5e-07 W=7e-07 AD=4.21667e-13 AS=5.95e-13 PD=1.33333e-06 PS=2.4e-06 NRD=0.607143 NRS=0.607143 $X=1450 $Y=6400 $D=41
M3 Q 5 vdd! vdd! pmos4 L=3.5e-07 W=1.4e-06 AD=9.45e-13 AS=8.43333e-13 PD=3.1e-06 PS=2.66667e-06 NRD=0.303571 NRS=0.303571 $X=2500 $Y=6975 $D=41
.ENDS
***************************************
.SUBCKT HAX3 B A CO vdd! gnd! SUM
** N=11 EP=6 IP=0 FDC=14
M0 10 A 8 gnd! nmos4 L=3.5e-07 W=6.75e-07 AD=2.7e-13 AS=5.9e-13 PD=8e-07 PS=2.425e-06 NRD=0.62963 NRS=0.62963 $X=1250 $Y=1850 $D=37
M1 gnd! B 10 gnd! nmos4 L=3.5e-07 W=6.75e-07 AD=3.41182e-13 AS=2.7e-13 PD=9.94091e-07 PS=8e-07 NRD=0.62963 NRS=0.62963 $X=2400 $Y=1850 $D=37
M2 7 8 gnd! gnd! nmos4 L=3.5e-07 W=7e-07 AD=3.5e-13 AS=3.53818e-13 PD=1e-06 PS=1.03091e-06 NRD=0.607143 NRS=0.607143 $X=3750 $Y=1825 $D=37
M3 9 A 7 gnd! nmos4 L=3.5e-07 W=7e-07 AD=5.25e-13 AS=3.5e-13 PD=2.1e-06 PS=1e-06 NRD=0.607143 NRS=0.607143 $X=5100 $Y=1825 $D=37
M4 7 B 9 gnd! nmos4 L=3.5e-07 W=7e-07 AD=5.95e-13 AS=5.25e-13 PD=2.4e-06 PS=2.1e-06 NRD=0.607143 NRS=0.607143 $X=6500 $Y=2875 $D=37
M5 gnd! 8 CO gnd! nmos4 L=3.5e-07 W=1.2e-06 AD=8e-13 AS=1.02e-12 PD=2.7e-06 PS=2.9e-06 NRD=0.354167 NRS=0.354167 $X=9700 $Y=2800 $D=37
M6 SUM 9 gnd! gnd! nmos4 L=3.5e-07 W=1.2e-06 AD=1.02e-12 AS=8e-13 PD=2.9e-06 PS=2.7e-06 NRD=0.354167 NRS=0.354167 $X=10750 $Y=2800 $D=37
M7 8 A vdd! vdd! pmos4 L=3.5e-07 W=1.1e-06 AD=5.5e-13 AS=9.35e-13 PD=1e-06 PS=2.8e-06 NRD=0.386364 NRS=0.386364 $X=1200 $Y=7900 $D=41
M8 vdd! B 8 vdd! pmos4 L=3.5e-07 W=1.1e-06 AD=5.5e-13 AS=5.5e-13 PD=1.00435e-06 PS=1e-06 NRD=0.386364 NRS=0.386364 $X=2550 $Y=7900 $D=41
M9 9 8 vdd! vdd! pmos4 L=3.5e-07 W=1.2e-06 AD=6e-13 AS=6e-13 PD=1e-06 PS=1.09565e-06 NRD=0.354167 NRS=0.354167 $X=3900 $Y=7800 $D=41
M10 11 A 9 vdd! pmos4 L=3.5e-07 W=1.2e-06 AD=2.7e-13 AS=6e-13 PD=4.5e-07 PS=1e-06 NRD=0.354167 NRS=0.354167 $X=5250 $Y=7800 $D=41
M11 vdd! B 11 vdd! pmos4 L=3.5e-07 W=1.2e-06 AD=1.22e-12 AS=2.7e-13 PD=3.4e-06 PS=4.5e-07 NRD=0.354167 NRS=0.354167 $X=6050 $Y=7800 $D=41
M12 vdd! 8 CO vdd! pmos4 L=3.5e-07 W=2.1e-06 AD=1.2075e-12 AS=1.785e-12 PD=1.75e-06 PS=3.8e-06 NRD=0.202381 NRS=0.202381 $X=9500 $Y=6400 $D=41
M13 SUM 9 vdd! vdd! pmos4 L=3.5e-07 W=2.1e-06 AD=1.785e-12 AS=1.2075e-12 PD=3.8e-06 PS=1.75e-06 NRD=0.202381 NRS=0.202381 $X=10900 $Y=7100 $D=41
.ENDS
***************************************
.SUBCKT FILLCELLX16
** N=2 EP=0 IP=0 FDC=0
.ENDS
***************************************
.SUBCKT ICV_101 1 2
*.CALIBRE ICV_CELL 9
** N=2 EP=2 IP=4 FDC=4
X0 1 2 ICV_100 $T=0 0 0 0 $X=-900 $Y=-1350
.ENDS
***************************************
.SUBCKT CLKINVX1 A vdd! gnd! Q
** N=4 EP=4 IP=0 FDC=2
M0 Q A gnd! gnd! nmos4 L=3.5e-07 W=4e-07 AD=5.7e-13 AS=1.45e-12 PD=2.8e-06 PS=6.5e-06 NRD=1.0625 NRS=1.0625 $X=1100 $Y=3450 $D=37
M1 Q A vdd! vdd! pmos4 L=3.5e-07 W=7e-07 AD=5.95e-13 AS=1.19e-12 PD=2.4e-06 PS=4.1e-06 NRD=0.607143 NRS=0.607143 $X=1250 $Y=6400 $D=41
.ENDS
***************************************
.SUBCKT CLKBUFX3 A vdd! gnd! Q
** N=5 EP=4 IP=0 FDC=4
M0 gnd! A 5 gnd! nmos4 L=3.5e-07 W=4e-07 AD=3.375e-13 AS=5.7e-13 PD=1.4e-06 PS=2.8e-06 NRD=1.0625 NRS=1.0625 $X=1200 $Y=2600 $D=37
M1 Q 5 gnd! gnd! nmos4 L=3.5e-07 W=1.2e-06 AD=8.45e-13 AS=1.0125e-12 PD=2.9e-06 PS=4.2e-06 NRD=0.354167 NRS=0.354167 $X=2250 $Y=2650 $D=37
M2 vdd! A 5 vdd! pmos4 L=3.5e-07 W=7e-07 AD=3.5875e-13 AS=5.95e-13 PD=8.75e-07 PS=2.4e-06 NRD=0.607143 NRS=0.607143 $X=1200 $Y=6400 $D=41
M3 Q 5 vdd! vdd! pmos4 L=3.5e-07 W=2.1e-06 AD=1.575e-12 AS=1.07625e-12 PD=3.8e-06 PS=2.625e-06 NRD=0.202381 NRS=0.202381 $X=2250 $Y=6400 $D=41
.ENDS
***************************************
.SUBCKT ICV_102 1 2 3 4 5 6 7 8
*.CALIBRE ICV_CELL 9
** N=8 EP=8 IP=10 FDC=40
X0 1 2 FILLCAPX2 $T=0 0 0 0 $X=-900 $Y=-1350
X1 3 4 5 6 7 8 1 2 DFCSX4 $T=2800 0 0 0 $X=1950 $Y=-1350
.ENDS
***************************************
.SUBCKT BUFX16 A gnd! Q vdd!
** N=5 EP=4 IP=0 FDC=10
M0 gnd! A 5 gnd! nmos4 L=3.5e-07 W=1.775e-06 AD=8.875e-13 AS=1.50875e-12 PD=1.06955e-06 PS=3.475e-06 NRD=0.239437 NRS=0.239437 $X=2700 $Y=1875 $D=37
M1 Q 5 gnd! gnd! nmos4 L=3.5e-07 W=2.125e-06 AD=1.0625e-12 AS=1.0625e-12 PD=1e-06 PS=1.28045e-06 NRD=0.2 NRS=0.2 $X=4050 $Y=1875 $D=37
M2 gnd! 5 Q gnd! nmos4 L=3.5e-07 W=2.125e-06 AD=1.0625e-12 AS=1.0625e-12 PD=1e-06 PS=1e-06 NRD=0.2 NRS=0.2 $X=5400 $Y=1875 $D=37
M3 Q 5 gnd! gnd! nmos4 L=3.5e-07 W=2.125e-06 AD=1.5875e-12 AS=1.0625e-12 PD=3.825e-06 PS=1e-06 NRD=0.2 NRS=0.2 $X=6750 $Y=1875 $D=37
M4 5 A vdd! vdd! pmos4 L=3.5e-07 W=1.55e-06 AD=7.75e-13 AS=1.3175e-12 PD=1e-06 PS=3.25e-06 NRD=0.274194 NRS=0.274194 $X=1350 $Y=7650 $D=41
M5 vdd! A 5 vdd! pmos4 L=3.5e-07 W=1.55e-06 AD=7.75e-13 AS=7.75e-13 PD=1.15805e-06 PS=1e-06 NRD=0.274194 NRS=0.274194 $X=2700 $Y=7650 $D=41
M6 Q 5 vdd! vdd! pmos4 L=3.5e-07 W=2.8e-06 AD=1.4e-12 AS=1.4e-12 PD=1e-06 PS=2.09195e-06 NRD=0.151786 NRS=0.151786 $X=4050 $Y=6400 $D=41
M7 vdd! 5 Q vdd! pmos4 L=3.5e-07 W=2.8e-06 AD=1.4e-12 AS=1.4e-12 PD=1e-06 PS=1e-06 NRD=0.151786 NRS=0.151786 $X=5400 $Y=6400 $D=41
M8 Q 5 vdd! vdd! pmos4 L=3.5e-07 W=2.8e-06 AD=1.4e-12 AS=1.4e-12 PD=1e-06 PS=1e-06 NRD=0.151786 NRS=0.151786 $X=6750 $Y=6400 $D=41
M9 vdd! 5 Q vdd! pmos4 L=3.5e-07 W=2.8e-06 AD=1.925e-12 AS=1.4e-12 PD=4.5e-06 PS=1e-06 NRD=0.151786 NRS=0.151786 $X=8100 $Y=6400 $D=41
.ENDS
***************************************
.SUBCKT CLKBUFX8 A Q gnd! vdd!
** N=5 EP=4 IP=0 FDC=6
M0 gnd! A 5 gnd! nmos4 L=3.5e-07 W=9e-07 AD=4.5e-13 AS=7.65e-13 PD=9.72e-07 PS=2.6e-06 NRD=0.472222 NRS=0.472222 $X=1200 $Y=1850 $D=37
M1 Q 5 gnd! gnd! nmos4 L=3.5e-07 W=1.6e-06 AD=8e-13 AS=8e-13 PD=1e-06 PS=1.728e-06 NRD=0.265625 NRS=0.265625 $X=2550 $Y=1850 $D=37
M2 gnd! 5 Q gnd! nmos4 L=3.5e-07 W=1.6e-06 AD=1.36e-12 AS=8e-13 PD=3.3e-06 PS=1e-06 NRD=0.265625 NRS=0.265625 $X=3900 $Y=1850 $D=37
M3 vdd! A 5 vdd! pmos4 L=3.5e-07 W=1.55e-06 AD=7.75e-13 AS=1.02e-12 PD=1.15805e-06 PS=3.25e-06 NRD=0.274194 NRS=0.274194 $X=1200 $Y=7650 $D=41
M4 Q 5 vdd! vdd! pmos4 L=3.5e-07 W=2.8e-06 AD=1.4e-12 AS=1.4e-12 PD=1e-06 PS=2.09195e-06 NRD=0.151786 NRS=0.151786 $X=2550 $Y=6400 $D=41
M5 vdd! 5 Q vdd! pmos4 L=3.5e-07 W=2.8e-06 AD=1.925e-12 AS=1.4e-12 PD=4.5e-06 PS=1e-06 NRD=0.151786 NRS=0.151786 $X=3900 $Y=6400 $D=41
.ENDS
***************************************
.SUBCKT DFCSX2 SE SI D CP RN Q vdd! gnd!
** N=26 EP=8 IP=0 FDC=38
M0 gnd! SE 9 gnd! nmos4 L=3.5e-07 W=5e-07 AD=6.25e-13 AS=1.15e-12 PD=2.1e-06 PS=4.3e-06 NRD=0.85 NRS=0.85 $X=1350 $Y=2500 $D=37
M1 22 SI gnd! gnd! nmos4 L=3.5e-07 W=5e-07 AD=1.125e-13 AS=6.25e-13 PD=4.5e-07 PS=2.1e-06 NRD=0.85 NRS=0.85 $X=2800 $Y=2500 $D=37
M2 14 SE 22 gnd! nmos4 L=3.5e-07 W=5e-07 AD=3.45e-13 AS=1.125e-13 PD=1.3e-06 PS=4.5e-07 NRD=0.85 NRS=0.85 $X=3600 $Y=2500 $D=37
M3 10 9 14 gnd! nmos4 L=3.5e-07 W=5e-07 AD=5.95e-13 AS=3.45e-13 PD=2.2e-06 PS=1.3e-06 NRD=0.85 NRS=0.85 $X=5050 $Y=2500 $D=37
M4 gnd! D 10 gnd! nmos4 L=3.5e-07 W=5e-07 AD=5.8875e-13 AS=5.95e-13 PD=2.7e-06 PS=2.2e-06 NRD=0.85 NRS=0.85 $X=7150 $Y=2500 $D=37
M5 gnd! CP 11 gnd! nmos4 L=3.5e-07 W=5e-07 AD=8.75e-13 AS=5.9e-13 PD=3.3e-06 PS=2.7e-06 NRD=0.85 NRS=0.85 $X=10700 $Y=2750 $D=37
M6 12 11 gnd! gnd! nmos4 L=3.5e-07 W=5e-07 AD=1.015e-12 AS=8.75e-13 PD=5e-06 PS=3.3e-06 NRD=0.85 NRS=0.85 $X=12800 $Y=2550 $D=37
M7 16 11 14 gnd! nmos4 L=3.5e-07 W=5e-07 AD=3.825e-13 AS=5.9e-13 PD=1.45e-06 PS=2.7e-06 NRD=0.85 NRS=0.85 $X=15750 $Y=2150 $D=37
M8 23 12 16 gnd! nmos4 L=3.5e-07 W=5e-07 AD=1.125e-13 AS=3.825e-13 PD=4.5e-07 PS=1.45e-06 NRD=0.85 NRS=0.85 $X=17350 $Y=2350 $D=37
M9 24 17 23 gnd! nmos4 L=3.5e-07 W=5e-07 AD=1.125e-13 AS=1.125e-13 PD=4.5e-07 PS=4.5e-07 NRD=0.85 NRS=0.85 $X=18150 $Y=2350 $D=37
M10 gnd! RN 24 gnd! nmos4 L=3.5e-07 W=5e-07 AD=7.4875e-13 AS=1.125e-13 PD=2.875e-06 PS=4.5e-07 NRD=0.85 NRS=0.85 $X=18950 $Y=2350 $D=37
M11 17 16 gnd! gnd! nmos4 L=3.5e-07 W=5e-07 AD=4.7375e-13 AS=7.4875e-13 PD=1.725e-06 PS=2.875e-06 NRD=0.85 NRS=0.85 $X=21000 $Y=2525 $D=37
M12 18 12 17 gnd! nmos4 L=3.5e-07 W=5e-07 AD=5.4875e-13 AS=4.7375e-13 PD=2.025e-06 PS=1.725e-06 NRD=0.85 NRS=0.85 $X=22650 $Y=2525 $D=37
M13 20 11 18 gnd! nmos4 L=3.5e-07 W=5e-07 AD=9.24375e-13 AS=5.4875e-13 PD=3.3e-06 PS=2.025e-06 NRD=0.85 NRS=0.85 $X=24600 $Y=2525 $D=37
M14 gnd! 19 20 gnd! nmos4 L=3.5e-07 W=5e-07 AD=6.775e-13 AS=9.24375e-13 PD=2.25e-06 PS=3.3e-06 NRD=0.85 NRS=0.85 $X=27250 $Y=2500 $D=37
M15 25 RN gnd! gnd! nmos4 L=3.5e-07 W=5e-07 AD=1.125e-13 AS=6.775e-13 PD=4.5e-07 PS=2.25e-06 NRD=0.85 NRS=0.85 $X=28700 $Y=2500 $D=37
M16 19 18 25 gnd! nmos4 L=3.5e-07 W=5e-07 AD=7.65e-13 AS=1.125e-13 PD=3.2e-06 PS=4.5e-07 NRD=0.85 NRS=0.85 $X=29500 $Y=2500 $D=37
M17 gnd! 19 Q gnd! nmos4 L=3.5e-07 W=8e-07 AD=4.5e-13 AS=1.18e-12 PD=1.125e-06 PS=3.75e-06 NRD=0.53125 NRS=0.53125 $X=33425 $Y=2650 $D=37
M18 QN 20 gnd! gnd! nmos4 L=3.5e-07 W=8e-07 AD=6.8e-13 AS=4.5e-13 PD=2.5e-06 PS=1.125e-06 NRD=0.53125 NRS=0.53125 $X=34900 $Y=2650 $D=37
M19 vdd! SE 9 vdd! pmos4 L=3.5e-07 W=1.05e-06 AD=5.25e-13 AS=8.925e-13 PD=1e-06 PS=2.75e-06 NRD=0.404762 NRS=0.404762 $X=1575 $Y=6700 $D=41
M20 26 SI vdd! vdd! pmos4 L=3.5e-07 W=1.05e-06 AD=2.3625e-13 AS=5.25e-13 PD=4.5e-07 PS=1e-06 NRD=0.404762 NRS=0.404762 $X=2925 $Y=6700 $D=41
M21 13 9 26 vdd! pmos4 L=3.5e-07 W=1.05e-06 AD=5.25e-13 AS=2.3625e-13 PD=1e-06 PS=4.5e-07 NRD=0.404762 NRS=0.404762 $X=3725 $Y=6700 $D=41
M22 10 SE 13 vdd! pmos4 L=3.5e-07 W=1.05e-06 AD=9.05625e-13 AS=5.25e-13 PD=1.725e-06 PS=1e-06 NRD=0.404762 NRS=0.404762 $X=5075 $Y=6700 $D=41
M23 vdd! D 10 vdd! pmos4 L=3.5e-07 W=1.05e-06 AD=9.1875e-13 AS=9.05625e-13 PD=2.8e-06 PS=1.725e-06 NRD=0.404762 NRS=0.404762 $X=7150 $Y=6700 $D=41
M24 vdd! CP 11 vdd! pmos4 L=3.5e-07 W=1.05e-06 AD=1.53125e-12 AS=8.925e-13 PD=3.45e-06 PS=2.75e-06 NRD=0.404762 NRS=0.404762 $X=10650 $Y=6400 $D=41
M25 12 11 vdd! vdd! pmos4 L=3.5e-07 W=1.05e-06 AD=8.925e-13 AS=1.53125e-12 PD=2.75e-06 PS=3.45e-06 NRD=0.404762 NRS=0.404762 $X=12850 $Y=6400 $D=41
M26 16 12 13 vdd! pmos4 L=3.5e-07 W=1.05e-06 AD=5.25e-13 AS=8.925e-13 PD=1e-06 PS=2.75e-06 NRD=0.404762 NRS=0.404762 $X=15500 $Y=7150 $D=41
M27 15 11 16 vdd! pmos4 L=3.5e-07 W=1.05e-06 AD=5.25e-13 AS=5.25e-13 PD=1e-06 PS=1e-06 NRD=0.404762 NRS=0.404762 $X=16850 $Y=7150 $D=41
M28 vdd! 17 15 vdd! pmos4 L=3.5e-07 W=1.05e-06 AD=5.25e-13 AS=5.25e-13 PD=1e-06 PS=1e-06 NRD=0.404762 NRS=0.404762 $X=18200 $Y=7150 $D=41
M29 15 RN vdd! vdd! pmos4 L=3.5e-07 W=1.05e-06 AD=8.925e-13 AS=5.25e-13 PD=2.75e-06 PS=1e-06 NRD=0.404762 NRS=0.404762 $X=19550 $Y=7150 $D=41
M30 17 16 vdd! vdd! pmos4 L=3.5e-07 W=1.05e-06 AD=6.5625e-13 AS=8.925e-13 PD=1.25e-06 PS=2.75e-06 NRD=0.404762 NRS=0.404762 $X=22200 $Y=6450 $D=41
M31 18 11 17 vdd! pmos4 L=3.5e-07 W=1.05e-06 AD=5.25e-13 AS=6.5625e-13 PD=1e-06 PS=1.25e-06 NRD=0.404762 NRS=0.404762 $X=23800 $Y=6450 $D=41
M32 20 12 18 vdd! pmos4 L=3.5e-07 W=1.05e-06 AD=7.0875e-13 AS=5.25e-13 PD=1.35e-06 PS=1e-06 NRD=0.404762 NRS=0.404762 $X=25150 $Y=6450 $D=41
M33 vdd! 19 20 vdd! pmos4 L=3.5e-07 W=1.05e-06 AD=7.875e-13 AS=7.0875e-13 PD=1.5e-06 PS=1.35e-06 NRD=0.404762 NRS=0.404762 $X=26850 $Y=6450 $D=41
M34 19 RN vdd! vdd! pmos4 L=3.5e-07 W=1.05e-06 AD=9.1875e-13 AS=7.875e-13 PD=1.75e-06 PS=1.5e-06 NRD=0.404762 NRS=0.404762 $X=28700 $Y=6450 $D=41
M35 vdd! 18 19 vdd! pmos4 L=3.5e-07 W=1.05e-06 AD=8.925e-13 AS=9.1875e-13 PD=2.75e-06 PS=1.75e-06 NRD=0.404762 NRS=0.404762 $X=30800 $Y=6450 $D=41
M36 vdd! 19 Q vdd! pmos4 L=3.5e-07 W=1.4e-06 AD=7e-13 AS=1.19e-12 PD=1e-06 PS=3.1e-06 NRD=0.303571 NRS=0.303571 $X=33450 $Y=6700 $D=41
M37 QN 20 vdd! vdd! pmos4 L=3.5e-07 W=1.4e-06 AD=1.0675e-12 AS=7e-13 PD=3.1e-06 PS=1e-06 NRD=0.303571 NRS=0.303571 $X=34800 $Y=6700 $D=41
.ENDS
***************************************
.SUBCKT CLKBUFX24 A gnd! Q vdd!
** N=5 EP=4 IP=0 FDC=13
M0 gnd! A 5 gnd! nmos4 L=3.5e-07 W=2.675e-06 AD=1.3375e-12 AS=1.8625e-12 PD=1.19914e-06 PS=4.375e-06 NRD=0.158879 NRS=0.158879 $X=2700 $Y=1325 $D=37
M1 Q 5 gnd! gnd! nmos4 L=3.5e-07 W=2.4e-06 AD=1.2e-12 AS=1.2e-12 PD=1e-06 PS=1.07586e-06 NRD=0.177083 NRS=0.177083 $X=4050 $Y=1600 $D=37
M2 gnd! 5 Q gnd! nmos4 L=3.5e-07 W=2.4e-06 AD=1.2e-12 AS=1.2e-12 PD=1e-06 PS=1e-06 NRD=0.177083 NRS=0.177083 $X=5400 $Y=1600 $D=37
M3 Q 5 gnd! gnd! nmos4 L=3.5e-07 W=2.4e-06 AD=1.2e-12 AS=1.2e-12 PD=1e-06 PS=1e-06 NRD=0.177083 NRS=0.177083 $X=6750 $Y=1600 $D=37
M4 gnd! 5 Q gnd! nmos4 L=3.5e-07 W=2.4e-06 AD=1.725e-12 AS=1.2e-12 PD=4.1e-06 PS=1e-06 NRD=0.177083 NRS=0.177083 $X=8100 $Y=1600 $D=37
M5 5 A vdd! vdd! pmos4 L=3.5e-07 W=2.325e-06 AD=1.1625e-12 AS=1.6875e-12 PD=1e-06 PS=4.025e-06 NRD=0.182796 NRS=0.182796 $X=1350 $Y=6875 $D=41
M6 vdd! A 5 vdd! pmos4 L=3.5e-07 W=2.325e-06 AD=1.1625e-12 AS=1.1625e-12 PD=1.1228e-06 PS=1e-06 NRD=0.182796 NRS=0.182796 $X=2700 $Y=6875 $D=41
M7 Q 5 vdd! vdd! pmos4 L=3.5e-07 W=2.8e-06 AD=1.4e-12 AS=1.4e-12 PD=1e-06 PS=1.3522e-06 NRD=0.151786 NRS=0.151786 $X=4050 $Y=6400 $D=41
M8 vdd! 5 Q vdd! pmos4 L=3.5e-07 W=2.8e-06 AD=1.4e-12 AS=1.4e-12 PD=1e-06 PS=1e-06 NRD=0.151786 NRS=0.151786 $X=5400 $Y=6400 $D=41
M9 Q 5 vdd! vdd! pmos4 L=3.5e-07 W=2.8e-06 AD=1.4e-12 AS=1.4e-12 PD=1e-06 PS=1e-06 NRD=0.151786 NRS=0.151786 $X=6750 $Y=6400 $D=41
M10 vdd! 5 Q vdd! pmos4 L=3.5e-07 W=2.8e-06 AD=1.4e-12 AS=1.4e-12 PD=1e-06 PS=1e-06 NRD=0.151786 NRS=0.151786 $X=8100 $Y=6400 $D=41
M11 Q 5 vdd! vdd! pmos4 L=3.5e-07 W=2.8e-06 AD=1.4e-12 AS=1.4e-12 PD=1e-06 PS=1e-06 NRD=0.151786 NRS=0.151786 $X=9450 $Y=6400 $D=41
M12 vdd! 5 Q vdd! pmos4 L=3.5e-07 W=2.8e-06 AD=1.925e-12 AS=1.4e-12 PD=4.5e-06 PS=1e-06 NRD=0.151786 NRS=0.151786 $X=10800 $Y=6400 $D=41
.ENDS
***************************************
.SUBCKT il2244_dig fECG_gain<2> fECG_gain<1> fECG_gain<0> fECG_filter<2> fECG_filter<1> fECG_filter<0> fECG_BG_sel ECG_gain<3> reset_l porborn ECG_gain<1> ECG_gain<2> SPI_Clk ECG_gain<0> ECG_filter<2> ECG_filter<1> SPI_MOSI ECG_filter<0> SPI_CS ECG_BG_sel
+ Bio_Ptat_EN Bio_Gain<3> Bio_Gain<2> Bio_Gain<1> Bio_Gain<0> Bio_Calib_EN gnd! vdd!
** N=217 EP=28 IP=1337 FDC=3358
D0 gnd! vdd! p_nwd AREA=2712.11 PJ=542.4 $X=14500 $Y=176800 $D=87
D1 gnd! vdd! p_nwd AREA=2711.8 PJ=542.3 $X=14500 $Y=197600 $D=87
D2 gnd! vdd! p_nwd AREA=2712.11 PJ=542.4 $X=14500 $Y=239200 $D=87
D3 gnd! vdd! p_nwd AREA=2712.11 PJ=542.4 $X=14500 $Y=135200 $D=87
D4 gnd! vdd! p_nwd AREA=2712.32 PJ=542.4 $X=14500 $Y=156000 $D=87
D5 gnd! vdd! p_nwd AREA=2712.11 PJ=542.4 $X=14500 $Y=218400 $D=87
D6 gnd! vdd! p_nwd AREA=2712.11 PJ=542.4 $X=14500 $Y=114400 $D=87
D7 gnd! vdd! p_nwd AREA=2711.8 PJ=542.3 $X=14500 $Y=31200 $D=87
D8 gnd! vdd! p_nwd AREA=2712.11 PJ=542.4 $X=14500 $Y=52000 $D=87
D9 gnd! vdd! p_nwd AREA=2712.11 PJ=542.4 $X=14500 $Y=93600 $D=87
D10 gnd! vdd! p_nwd AREA=2712.11 PJ=542.4 $X=14500 $Y=72800 $D=87
D11 gnd! vdd! p_nwd AREA=1629.69 PJ=534 $X=14500 $Y=14550 $D=87
M12 gnd! 35 179 gnd! nmos4 L=3.5e-07 W=5e-07 AD=4.2375e-13 AS=7.4e-13 PD=1.525e-06 PS=3.7e-06 NRD=0.85 NRS=0.85 $X=50700 $Y=173400 $D=37
M13 180 179 gnd! gnd! nmos4 L=3.5e-07 W=5e-07 AD=1.15e-12 AS=4.2375e-13 PD=4.3e-06 PS=1.525e-06 NRD=0.85 NRS=0.85 $X=52150 $Y=173400 $D=37
M14 203 179 gnd! gnd! nmos4 L=3.5e-07 W=5e-07 AD=2.25e-13 AS=1.15e-12 PD=9e-07 PS=4.3e-06 NRD=0.85 NRS=0.85 $X=55050 $Y=174525 $D=37
M15 176 132 203 gnd! nmos4 L=3.5e-07 W=5e-07 AD=6.75625e-13 AS=2.25e-13 PD=2.625e-06 PS=9e-07 NRD=0.85 NRS=0.85 $X=56300 $Y=174525 $D=37
M16 204 180 176 gnd! nmos4 L=3.5e-07 W=5e-07 AD=1.125e-13 AS=6.75625e-13 PD=4.5e-07 PS=2.625e-06 NRD=0.85 NRS=0.85 $X=59075 $Y=174350 $D=37
M17 205 178 204 gnd! nmos4 L=3.5e-07 W=5e-07 AD=1.125e-13 AS=1.125e-13 PD=4.5e-07 PS=4.5e-07 NRD=0.85 NRS=0.85 $X=59875 $Y=174350 $D=37
M18 gnd! 47 205 gnd! nmos4 L=3.5e-07 W=5e-07 AD=7.5375e-13 AS=1.125e-13 PD=2.475e-06 PS=4.5e-07 NRD=0.85 NRS=0.85 $X=60675 $Y=174350 $D=37
M19 178 176 gnd! gnd! nmos4 L=3.5e-07 W=5e-07 AD=6.3875e-13 AS=7.5375e-13 PD=2.475e-06 PS=2.475e-06 NRD=0.85 NRS=0.85 $X=62150 $Y=174350 $D=37
M20 181 180 178 gnd! nmos4 L=3.5e-07 W=5e-07 AD=6.5e-13 AS=6.3875e-13 PD=2.2e-06 PS=2.475e-06 NRD=0.85 NRS=0.85 $X=64775 $Y=174550 $D=37
M21 183 179 181 gnd! nmos4 L=3.5e-07 W=5e-07 AD=5.9e-13 AS=6.5e-13 PD=2.7e-06 PS=2.2e-06 NRD=0.85 NRS=0.85 $X=66325 $Y=174550 $D=37
M22 gnd! 182 183 gnd! nmos4 L=3.5e-07 W=5e-07 AD=8e-13 AS=9.15e-13 PD=2.6e-06 PS=4e-06 NRD=0.85 NRS=0.85 $X=69725 $Y=174350 $D=37
M23 206 47 gnd! gnd! nmos4 L=3.5e-07 W=5e-07 AD=1.125e-13 AS=8e-13 PD=4.5e-07 PS=2.6e-06 NRD=0.85 NRS=0.85 $X=71175 $Y=174350 $D=37
M24 182 181 206 gnd! nmos4 L=3.5e-07 W=5e-07 AD=7.3e-13 AS=1.125e-13 PD=3.1e-06 PS=4.5e-07 NRD=0.85 NRS=0.85 $X=71975 $Y=174350 $D=37
M25 gnd! 182 37 gnd! nmos4 L=3.5e-07 W=1.2e-06 AD=6e-13 AS=8.45e-13 PD=1e-06 PS=2.9e-06 NRD=0.354167 NRS=0.354167 $X=75500 $Y=174400 $D=37
M26 39 183 gnd! gnd! nmos4 L=3.5e-07 W=1.2e-06 AD=8.45e-13 AS=6e-13 PD=2.9e-06 PS=1e-06 NRD=0.354167 NRS=0.354167 $X=76850 $Y=174400 $D=37
M27 35 184 gnd! gnd! nmos4 L=3.5e-07 W=1.6e-06 AD=8e-13 AS=1.36e-12 PD=1e-06 PS=3.3e-06 NRD=0.265625 NRS=0.265625 $X=86750 $Y=194250 $D=37
M28 gnd! 184 35 gnd! nmos4 L=3.5e-07 W=1.6e-06 AD=8e-13 AS=8e-13 PD=1.728e-06 PS=1e-06 NRD=0.265625 NRS=0.265625 $X=88100 $Y=194250 $D=37
M29 184 138 gnd! gnd! nmos4 L=3.5e-07 W=9e-07 AD=7.65e-13 AS=4.5e-13 PD=2.6e-06 PS=9.72e-07 NRD=0.472222 NRS=0.472222 $X=89450 $Y=194250 $D=37
M30 gnd! 185 138 gnd! nmos4 L=3.5e-07 W=8e-07 AD=7.66667e-13 AS=6.8e-13 PD=3.46667e-06 PS=2.5e-06 NRD=0.53125 NRS=0.53125 $X=90950 $Y=251350 $D=37
M31 185 SPI_Clk gnd! gnd! nmos4 L=3.5e-07 W=4e-07 AD=5.7e-13 AS=3.83333e-13 PD=2.8e-06 PS=1.73333e-06 NRD=1.0625 NRS=1.0625 $X=92000 $Y=251800 $D=37
M32 gnd! 143 47 gnd! nmos4 L=3.5e-07 W=1.6e-06 AD=1.36e-12 AS=1.045e-12 PD=3.3e-06 PS=3.3e-06 NRD=0.265625 NRS=0.265625 $X=104900 $Y=147700 $D=37
M33 189 136 gnd! gnd! nmos4 L=3.5e-07 W=4e-07 AD=3.25e-13 AS=1.43e-12 PD=1.4e-06 PS=6.4e-06 NRD=1.0625 NRS=1.0625 $X=111425 $Y=167800 $D=37
M34 gnd! 142 189 gnd! nmos4 L=3.5e-07 W=4e-07 AD=7.5625e-13 AS=3.25e-13 PD=3.2e-06 PS=1.4e-06 NRD=1.0625 NRS=1.0625 $X=112875 $Y=167775 $D=37
M35 189 50 gnd! gnd! nmos4 L=3.5e-07 W=4e-07 AD=5.8125e-13 AS=7.5625e-13 PD=2.175e-06 PS=3.2e-06 NRD=1.0625 NRS=1.0625 $X=113950 $Y=168675 $D=37
M36 gnd! 59 187 gnd! nmos4 L=3.5e-07 W=1.325e-06 AD=6.625e-13 AS=9.075e-13 PD=1.09379e-06 PS=3.025e-06 NRD=0.320755 NRS=0.320755 $X=114600 $Y=231075 $D=37
M37 gnd! 145 189 gnd! nmos4 L=3.5e-07 W=4e-07 AD=8.7e-13 AS=5.8125e-13 PD=4.8e-06 PS=2.175e-06 NRD=1.0625 NRS=1.0625 $X=115400 $Y=168600 $D=37
M38 53 187 gnd! gnd! nmos4 L=3.5e-07 W=2.4e-06 AD=1.2e-12 AS=1.2e-12 PD=1e-06 PS=1.98121e-06 NRD=0.177083 NRS=0.177083 $X=115950 $Y=230000 $D=37
M39 gnd! 187 53 gnd! nmos4 L=3.5e-07 W=2.4e-06 AD=1.725e-12 AS=1.2e-12 PD=4.1e-06 PS=1e-06 NRD=0.177083 NRS=0.177083 $X=117300 $Y=230000 $D=37
M40 45 155 gnd! gnd! nmos4 L=3.5e-07 W=2.4e-06 AD=1.2e-12 AS=1.725e-12 PD=1e-06 PS=4.1e-06 NRD=0.177083 NRS=0.177083 $X=126675 $Y=126000 $D=37
M41 190 57 gnd! gnd! nmos4 L=3.5e-07 W=4e-07 AD=6.05e-13 AS=1.13e-12 PD=2.2e-06 PS=4.4e-06 NRD=1.0625 NRS=1.0625 $X=127500 $Y=189500 $D=37
M42 207 149 gnd! gnd! nmos4 L=3.5e-07 W=4.75e-07 AD=1.06875e-13 AS=1.145e-12 PD=4.5e-07 PS=4.325e-06 NRD=0.894737 NRS=0.894737 $X=127800 $Y=168625 $D=37
M43 gnd! 82 45 gnd! nmos4 L=3.5e-07 W=2.4e-06 AD=1.725e-12 AS=1.2e-12 PD=4.1e-06 PS=1e-06 NRD=0.177083 NRS=0.177083 $X=128025 $Y=126000 $D=37
M44 208 82 gnd! gnd! nmos4 L=3.5e-07 W=8.75e-07 AD=1.96875e-13 AS=7.4375e-13 PD=4.5e-07 PS=2.575e-06 NRD=0.485714 NRS=0.485714 $X=128600 $Y=111500 $D=37
M45 209 189 207 gnd! nmos4 L=3.5e-07 W=4.75e-07 AD=2.1375e-13 AS=1.06875e-13 PD=9e-07 PS=4.5e-07 NRD=0.894737 NRS=0.894737 $X=128600 $Y=168625 $D=37
M46 gnd! 150 190 gnd! nmos4 L=3.5e-07 W=4e-07 AD=2.53333e-13 AS=6.05e-13 PD=8.33333e-07 PS=2.2e-06 NRD=1.0625 NRS=1.0625 $X=128950 $Y=189500 $D=37
M47 60 154 208 gnd! nmos4 L=3.5e-07 W=8.75e-07 AD=7.4375e-13 AS=1.96875e-13 PD=2.575e-06 PS=4.5e-07 NRD=0.485714 NRS=0.485714 $X=129400 $Y=111500 $D=37
M48 155 150 209 gnd! nmos4 L=3.5e-07 W=4.75e-07 AD=1.145e-12 AS=2.1375e-13 PD=4.325e-06 PS=9e-07 NRD=0.894737 NRS=0.894737 $X=129850 $Y=168625 $D=37
M49 58 190 gnd! gnd! nmos4 L=3.5e-07 W=8e-07 AD=4e-13 AS=5.06667e-13 PD=9.91045e-07 PS=1.66667e-06 NRD=0.53125 NRS=0.53125 $X=130350 $Y=189500 $D=37
M50 gnd! 152 191 gnd! nmos4 L=3.5e-07 W=6.75e-07 AD=3.46829e-13 AS=5.9e-13 PD=8.39634e-07 PS=2.425e-06 NRD=0.62963 NRS=0.62963 $X=131625 $Y=230000 $D=37
M51 210 57 58 gnd! nmos4 L=3.5e-07 W=8.75e-07 AD=1.96875e-13 AS=4.375e-13 PD=4.5e-07 PS=1.08396e-06 NRD=0.485714 NRS=0.485714 $X=131700 $Y=189425 $D=37
M52 gnd! 150 210 gnd! nmos4 L=3.5e-07 W=8.75e-07 AD=7.4375e-13 AS=1.96875e-13 PD=2.575e-06 PS=4.5e-07 NRD=0.485714 NRS=0.485714 $X=132500 $Y=189425 $D=37
M53 95 191 gnd! gnd! nmos4 L=3.5e-07 W=2.4e-06 AD=1.725e-12 AS=1.23317e-12 PD=4.1e-06 PS=2.98537e-06 NRD=0.177083 NRS=0.177083 $X=132675 $Y=230000 $D=37
M54 gnd! SPI_CS 195 gnd! nmos4 L=3.5e-07 W=4.5e-07 AD=5.67439e-13 AS=1.14e-12 PD=1.94268e-06 PS=4.35e-06 NRD=0.944444 NRS=0.944444 $X=192000 $Y=251850 $D=37
M55 196 195 gnd! gnd! nmos4 L=2e-06 W=5.75e-07 AD=1.165e-12 AS=7.25061e-13 PD=4.225e-06 PS=2.48232e-06 NRD=0.73913 NRS=0.73913 $X=193450 $Y=251725 $D=37
M56 gnd! 196 197 gnd! nmos4 L=2e-06 W=5.75e-07 AD=6.05e-13 AS=1.165e-12 PD=2.625e-06 PS=4.225e-06 NRD=0.73913 NRS=0.73913 $X=197875 $Y=250800 $D=37
M57 93 197 gnd! gnd! nmos4 L=3.5e-07 W=1.15e-06 AD=9.775e-13 AS=9.775e-13 PD=2.85e-06 PS=2.85e-06 NRD=0.369565 NRS=0.369565 $X=202125 $Y=251850 $D=37
M58 gnd! 170 198 gnd! nmos4 L=3.5e-07 W=1.1e-06 AD=5.5e-13 AS=7.95e-13 PD=1.02903e-06 PS=2.8e-06 NRD=0.386364 NRS=0.386364 $X=211200 $Y=126900 $D=37
M59 34 198 gnd! gnd! nmos4 L=3.5e-07 W=2e-06 AD=1e-12 AS=1e-12 PD=1e-06 PS=1.87097e-06 NRD=0.2125 NRS=0.2125 $X=212550 $Y=126000 $D=37
M60 gnd! 198 34 gnd! nmos4 L=3.5e-07 W=2e-06 AD=1.525e-12 AS=1e-12 PD=3.7e-06 PS=1e-06 NRD=0.2125 NRS=0.2125 $X=213900 $Y=126000 $D=37
M61 vdd! 35 179 vdd! pmos4 L=3.5e-07 W=1.05e-06 AD=5.5125e-13 AS=8.925e-13 PD=1.05e-06 PS=2.75e-06 NRD=0.404762 NRS=0.404762 $X=50300 $Y=178000 $D=41
M62 180 179 vdd! vdd! pmos4 L=3.5e-07 W=1.05e-06 AD=1.6275e-12 AS=5.5125e-13 PD=4.15e-06 PS=1.05e-06 NRD=0.404762 NRS=0.404762 $X=51700 $Y=178000 $D=41
M63 211 180 vdd! vdd! pmos4 L=3.5e-07 W=1.05e-06 AD=2.3625e-13 AS=8.925e-13 PD=4.5e-07 PS=2.75e-06 NRD=0.404762 NRS=0.404762 $X=55850 $Y=178000 $D=41
M64 176 132 211 vdd! pmos4 L=3.5e-07 W=1.05e-06 AD=5.25e-13 AS=2.3625e-13 PD=1e-06 PS=4.5e-07 NRD=0.404762 NRS=0.404762 $X=56650 $Y=178000 $D=41
M65 177 179 176 vdd! pmos4 L=3.5e-07 W=1.05e-06 AD=5.25e-13 AS=5.25e-13 PD=1e-06 PS=1e-06 NRD=0.404762 NRS=0.404762 $X=58000 $Y=178000 $D=41
M66 vdd! 178 177 vdd! pmos4 L=3.5e-07 W=1.05e-06 AD=1.33e-12 AS=5.25e-13 PD=6.35e-06 PS=1e-06 NRD=0.404762 NRS=0.404762 $X=59350 $Y=178000 $D=41
M67 vdd! 47 177 vdd! pmos4 L=3.5e-07 W=1.05e-06 AD=7.7e-13 AS=7.7e-13 PD=2.85e-06 PS=2.75e-06 NRD=0.404762 NRS=0.404762 $X=61650 $Y=178000 $D=41
M68 178 176 vdd! vdd! pmos4 L=3.5e-07 W=1.05e-06 AD=8.3125e-13 AS=7.7e-13 PD=2.05e-06 PS=2.85e-06 NRD=0.404762 NRS=0.404762 $X=62700 $Y=178000 $D=41
M69 181 179 178 vdd! pmos4 L=3.5e-07 W=1.05e-06 AD=5.5125e-13 AS=8.3125e-13 PD=1.05e-06 PS=2.05e-06 NRD=0.404762 NRS=0.404762 $X=64750 $Y=178350 $D=41
M70 183 180 181 vdd! pmos4 L=3.5e-07 W=1.05e-06 AD=1.08937e-12 AS=5.5125e-13 PD=2.075e-06 PS=1.05e-06 NRD=0.404762 NRS=0.404762 $X=66150 $Y=178350 $D=41
M71 vdd! 182 183 vdd! pmos4 L=3.5e-07 W=1.05e-06 AD=8.5625e-13 AS=1.08937e-12 PD=3.05e-06 PS=2.075e-06 NRD=0.404762 NRS=0.404762 $X=68575 $Y=178350 $D=41
M72 182 47 vdd! vdd! pmos4 L=3.5e-07 W=1.05e-06 AD=9.1875e-13 AS=8.5625e-13 PD=1.75e-06 PS=3.05e-06 NRD=0.404762 NRS=0.404762 $X=69875 $Y=178050 $D=41
M73 vdd! 181 182 vdd! pmos4 L=3.5e-07 W=1.05e-06 AD=8.925e-13 AS=9.1875e-13 PD=2.75e-06 PS=1.75e-06 NRD=0.404762 NRS=0.404762 $X=71975 $Y=178050 $D=41
M74 vdd! 182 37 vdd! pmos4 L=3.5e-07 W=2.1e-06 AD=1.05e-12 AS=1.68e-12 PD=1e-06 PS=5.3e-06 NRD=0.202381 NRS=0.202381 $X=75500 $Y=178700 $D=41
M75 39 183 vdd! vdd! pmos4 L=3.5e-07 W=2.1e-06 AD=1.4175e-12 AS=1.05e-12 PD=3.8e-06 PS=1e-06 NRD=0.202381 NRS=0.202381 $X=76850 $Y=178700 $D=41
M76 35 184 vdd! vdd! pmos4 L=3.5e-07 W=2.8e-06 AD=1.4e-12 AS=1.925e-12 PD=1e-06 PS=4.5e-06 NRD=0.151786 NRS=0.151786 $X=86750 $Y=198800 $D=41
M77 vdd! 184 35 vdd! pmos4 L=3.5e-07 W=2.8e-06 AD=1.4e-12 AS=1.4e-12 PD=2.09195e-06 PS=1e-06 NRD=0.151786 NRS=0.151786 $X=88100 $Y=198800 $D=41
M78 184 138 vdd! vdd! pmos4 L=3.5e-07 W=1.55e-06 AD=1.02e-12 AS=7.75e-13 PD=3.25e-06 PS=1.15805e-06 NRD=0.274194 NRS=0.274194 $X=89450 $Y=200050 $D=41
M79 vdd! 185 138 vdd! pmos4 L=3.5e-07 W=1.4e-06 AD=8.43333e-13 AS=9.45e-13 PD=2.66667e-06 PS=3.1e-06 NRD=0.303571 NRS=0.303571 $X=90950 $Y=246425 $D=41
M80 185 SPI_Clk vdd! vdd! pmos4 L=3.5e-07 W=7e-07 AD=5.95e-13 AS=4.21667e-13 PD=2.4e-06 PS=1.33333e-06 NRD=0.607143 NRS=0.607143 $X=92000 $Y=247700 $D=41
M81 vdd! 143 47 vdd! pmos4 L=3.5e-07 W=2.8e-06 AD=1.925e-12 AS=1.925e-12 PD=4.5e-06 PS=4.5e-06 NRD=0.151786 NRS=0.151786 $X=104850 $Y=141600 $D=41
M82 212 136 vdd! vdd! pmos4 L=3.5e-07 W=9.25e-07 AD=2.08125e-13 AS=7.8625e-13 PD=4.5e-07 PS=2.625e-06 NRD=0.459459 NRS=0.459459 $X=112100 $Y=163625 $D=41
M83 213 142 212 vdd! pmos4 L=3.5e-07 W=9.25e-07 AD=2.08125e-13 AS=2.08125e-13 PD=4.5e-07 PS=4.5e-07 NRD=0.459459 NRS=0.459459 $X=112900 $Y=163625 $D=41
M84 214 50 213 vdd! pmos4 L=3.5e-07 W=9.25e-07 AD=2.08125e-13 AS=2.08125e-13 PD=4.5e-07 PS=4.5e-07 NRD=0.459459 NRS=0.459459 $X=113700 $Y=163625 $D=41
M85 189 145 214 vdd! pmos4 L=3.5e-07 W=9.25e-07 AD=7.8625e-13 AS=2.08125e-13 PD=2.625e-06 PS=4.5e-07 NRD=0.459459 NRS=0.459459 $X=114500 $Y=163625 $D=41
M86 vdd! 59 187 vdd! pmos4 L=3.5e-07 W=2.325e-06 AD=1.1625e-12 AS=1.6875e-12 PD=1.1228e-06 PS=4.025e-06 NRD=0.182796 NRS=0.182796 $X=114600 $Y=224800 $D=41
M87 53 187 vdd! vdd! pmos4 L=3.5e-07 W=2.8e-06 AD=1.4e-12 AS=1.4e-12 PD=1e-06 PS=1.3522e-06 NRD=0.151786 NRS=0.151786 $X=115950 $Y=224800 $D=41
M88 vdd! 187 53 vdd! pmos4 L=3.5e-07 W=2.8e-06 AD=1.4e-12 AS=1.4e-12 PD=1e-06 PS=1e-06 NRD=0.151786 NRS=0.151786 $X=117300 $Y=224800 $D=41
M89 53 187 vdd! vdd! pmos4 L=3.5e-07 W=2.8e-06 AD=1.9425e-12 AS=1.4e-12 PD=4.5e-06 PS=1e-06 NRD=0.151786 NRS=0.151786 $X=118650 $Y=224800 $D=41
M90 215 82 vdd! vdd! pmos4 L=3.5e-07 W=2.35e-06 AD=5.2875e-13 AS=1.7e-12 PD=4.5e-07 PS=4.05e-06 NRD=0.180851 NRS=0.180851 $X=124525 $Y=120800 $D=41
M91 45 155 215 vdd! pmos4 L=3.5e-07 W=2.35e-06 AD=1.175e-12 AS=5.2875e-13 PD=1e-06 PS=4.5e-07 NRD=0.180851 NRS=0.180851 $X=125325 $Y=120800 $D=41
M92 216 155 45 vdd! pmos4 L=3.5e-07 W=2.35e-06 AD=5.2875e-13 AS=1.175e-12 PD=4.5e-07 PS=1e-06 NRD=0.180851 NRS=0.180851 $X=126675 $Y=120800 $D=41
M93 155 149 vdd! vdd! pmos4 L=3.5e-07 W=7e-07 AD=3.5e-13 AS=5.95e-13 PD=1e-06 PS=2.4e-06 NRD=0.607143 NRS=0.607143 $X=127250 $Y=163850 $D=41
M94 vdd! 82 216 vdd! pmos4 L=3.5e-07 W=2.35e-06 AD=1.42e-12 AS=5.2875e-13 PD=4.05e-06 PS=4.5e-07 NRD=0.180851 NRS=0.180851 $X=127475 $Y=120800 $D=41
M95 217 57 190 vdd! pmos4 L=3.5e-07 W=7.75e-07 AD=2.13125e-13 AS=6.5875e-13 PD=5.5e-07 PS=2.475e-06 NRD=0.548387 NRS=0.548387 $X=127500 $Y=185225 $D=41
M96 vdd! 150 217 vdd! pmos4 L=3.5e-07 W=7.75e-07 AD=4.90833e-13 AS=2.13125e-13 PD=9.58333e-07 PS=5.5e-07 NRD=0.548387 NRS=0.548387 $X=128400 $Y=185225 $D=41
M97 60 82 vdd! vdd! pmos4 L=3.5e-07 W=1.4e-06 AD=7e-13 AS=9.45e-13 PD=1e-06 PS=3.1e-06 NRD=0.303571 NRS=0.303571 $X=128600 $Y=115700 $D=41
M98 vdd! 189 155 vdd! pmos4 L=3.5e-07 W=7e-07 AD=5.8e-13 AS=3.5e-13 PD=2.4e-06 PS=1e-06 NRD=0.607143 NRS=0.607143 $X=128600 $Y=163850 $D=41
M99 155 150 vdd! vdd! pmos4 L=3.5e-07 W=7e-07 AD=5.95e-13 AS=5.8e-13 PD=2.4e-06 PS=2.4e-06 NRD=0.607143 NRS=0.607143 $X=129650 $Y=163500 $D=41
M100 192 190 vdd! vdd! pmos4 L=3.5e-07 W=1.55e-06 AD=7.75e-13 AS=9.81667e-13 PD=1e-06 PS=1.91667e-06 NRD=0.274194 NRS=0.274194 $X=129800 $Y=184450 $D=41
M101 vdd! 154 60 vdd! pmos4 L=3.5e-07 W=1.4e-06 AD=1.685e-12 AS=7e-13 PD=6.25e-06 PS=1e-06 NRD=0.303571 NRS=0.303571 $X=129950 $Y=115700 $D=41
M102 58 57 192 vdd! pmos4 L=3.5e-07 W=1.55e-06 AD=7.75e-13 AS=7.75e-13 PD=1e-06 PS=1e-06 NRD=0.274194 NRS=0.274194 $X=131150 $Y=184450 $D=41
M103 vdd! 152 191 vdd! pmos4 L=3.5e-07 W=1.175e-06 AD=5.89294e-13 AS=8.325e-13 PD=1.35439e-06 PS=2.875e-06 NRD=0.361702 NRS=0.361702 $X=131625 $Y=226100 $D=41
M104 192 150 58 vdd! pmos4 L=3.5e-07 W=1.55e-06 AD=1.3175e-12 AS=7.75e-13 PD=3.25e-06 PS=1e-06 NRD=0.274194 NRS=0.274194 $X=132500 $Y=184450 $D=41
M105 95 191 vdd! vdd! pmos4 L=3.5e-07 W=2.1e-06 AD=1.05e-12 AS=1.05321e-12 PD=1e-06 PS=2.42061e-06 NRD=0.202381 NRS=0.202381 $X=132675 $Y=224800 $D=41
M106 vdd! 191 95 vdd! pmos4 L=3.5e-07 W=2.1e-06 AD=1.295e-12 AS=1.05e-12 PD=3.8e-06 PS=1e-06 NRD=0.202381 NRS=0.202381 $X=134025 $Y=224800 $D=41
M107 vdd! SPI_CS 195 vdd! pmos4 L=3.5e-07 W=8e-07 AD=4e-13 AS=6.8e-13 PD=9.33333e-07 PS=2.5e-06 NRD=0.53125 NRS=0.53125 $X=192000 $Y=246800 $D=41
M108 196 195 vdd! vdd! pmos4 L=2e-06 W=1.6e-06 AD=1.36e-12 AS=8e-13 PD=3.3e-06 PS=1.86667e-06 NRD=0.265625 NRS=0.265625 $X=193350 $Y=246800 $D=41
M109 vdd! 196 197 vdd! pmos4 L=2e-06 W=1.6e-06 AD=8e-13 AS=1.36e-12 PD=1e-06 PS=3.3e-06 NRD=0.265625 NRS=0.265625 $X=197775 $Y=246800 $D=41
M110 93 197 vdd! vdd! pmos4 L=2e-06 W=1.6e-06 AD=8e-13 AS=8e-13 PD=1e-06 PS=1e-06 NRD=0.265625 NRS=0.265625 $X=200775 $Y=246800 $D=41
M111 vdd! 197 93 vdd! pmos4 L=2e-06 W=1.6e-06 AD=1.36e-12 AS=8e-13 PD=3.3e-06 PS=1e-06 NRD=0.265625 NRS=0.265625 $X=203775 $Y=246800 $D=41
M112 vdd! 170 198 vdd! pmos4 L=3.5e-07 W=1.95e-06 AD=9.75e-13 AS=1.5e-12 PD=1.08333e-06 PS=3.65e-06 NRD=0.217949 NRS=0.217949 $X=211200 $Y=121100 $D=41
M113 34 198 vdd! vdd! pmos4 L=3.5e-07 W=2.325e-06 AD=1.1625e-12 AS=1.1625e-12 PD=1e-06 PS=1.29167e-06 NRD=0.182796 NRS=0.182796 $X=212550 $Y=121100 $D=41
M114 vdd! 198 34 vdd! pmos4 L=3.5e-07 W=2.325e-06 AD=1.1625e-12 AS=1.1625e-12 PD=1e-06 PS=1e-06 NRD=0.182796 NRS=0.182796 $X=213900 $Y=121100 $D=41
M115 34 198 vdd! vdd! pmos4 L=3.5e-07 W=2.325e-06 AD=1.6875e-12 AS=1.1625e-12 PD=4.025e-06 PS=1e-06 NRD=0.182796 NRS=0.182796 $X=215250 $Y=121100 $D=41
X116 gnd! vdd! FILLCAPX8 $T=15400 26000 0 0 $X=14500 $Y=24650
X117 gnd! vdd! FILLCAPX8 $T=15400 67600 1 0 $X=14500 $Y=55850
X118 gnd! vdd! FILLCAPX8 $T=15400 88400 0 0 $X=14500 $Y=87050
X119 gnd! vdd! FILLCAPX8 $T=82600 192400 1 0 $X=81700 $Y=180650
X120 gnd! vdd! FILLCAPX8 $T=135800 234000 1 0 $X=134900 $Y=222250
X121 gnd! vdd! FILLCAPX8 $T=207200 171600 1 180 $X=195100 $Y=170250
X122 gnd! vdd! FILLCAPX8 $T=200200 150800 0 0 $X=199300 $Y=149450
X123 gnd! vdd! FILLCAPX8 $T=207200 254800 1 0 $X=206300 $Y=243050
X124 gnd! vdd! FILLCAPX8 $T=268800 254800 0 180 $X=256700 $Y=243050
X125 gnd! vdd! FILLCAPX8 $T=259000 46800 1 0 $X=258100 $Y=35050
X126 gnd! vdd! FILLCAPX8 $T=263200 67600 1 0 $X=262300 $Y=55850
X127 gnd! vdd! FILLCAPX8 $T=263200 88400 1 0 $X=262300 $Y=76650
X128 gnd! vdd! FILLCAPX4 $T=15400 67600 0 0 $X=14500 $Y=66250
X129 gnd! vdd! FILLCAPX4 $T=15400 88400 1 0 $X=14500 $Y=76650
X130 gnd! vdd! FILLCAPX4 $T=37800 109200 1 0 $X=36900 $Y=97450
X131 gnd! vdd! FILLCAPX4 $T=37800 109200 0 0 $X=36900 $Y=107850
X132 gnd! vdd! FILLCAPX4 $T=82600 46800 0 0 $X=81700 $Y=45450
X133 gnd! vdd! FILLCAPX4 $T=117600 150800 0 0 $X=116700 $Y=149450
X134 gnd! vdd! FILLCAPX4 $T=119000 130000 0 0 $X=118100 $Y=128650
X135 gnd! vdd! FILLCAPX4 $T=156800 88400 0 0 $X=155900 $Y=87050
X136 gnd! vdd! FILLCAPX4 $T=158200 67600 1 0 $X=157300 $Y=55850
X137 gnd! vdd! FILLCAPX4 $T=182000 46800 0 0 $X=181100 $Y=45450
X138 gnd! vdd! FILLCAPX4 $T=208600 234000 0 0 $X=207700 $Y=232650
X139 gnd! vdd! FILLCAPX4 $T=212800 213200 1 0 $X=211900 $Y=201450
X140 gnd! vdd! FILLCAPX4 $T=217000 150800 1 0 $X=216100 $Y=139050
X141 gnd! vdd! FILLCAPX4 $T=264600 26000 0 0 $X=263700 $Y=24650
X142 gnd! vdd! FILLCAPX4 $T=264600 46800 0 0 $X=263700 $Y=45450
X143 gnd! vdd! FILLCAPX4 $T=271600 130000 1 180 $X=265100 $Y=128650
X144 gnd! vdd! FILLCAPX4 $T=268800 254800 1 0 $X=267900 $Y=243050
X145 gnd! vdd! ICV_100 $T=15400 26000 1 0 $X=14500 $Y=14250
X146 gnd! vdd! ICV_100 $T=37800 130000 0 0 $X=36900 $Y=128650
X147 gnd! vdd! ICV_100 $T=37800 150800 1 0 $X=36900 $Y=139050
X148 gnd! vdd! ICV_100 $T=63000 171600 1 0 $X=62100 $Y=159850
X149 gnd! vdd! ICV_100 $T=78400 88400 0 0 $X=77500 $Y=87050
X150 gnd! vdd! ICV_100 $T=89600 109200 0 0 $X=88700 $Y=107850
X151 gnd! vdd! ICV_100 $T=103600 67600 1 0 $X=102700 $Y=55850
X152 gnd! vdd! ICV_100 $T=123200 46800 0 0 $X=122300 $Y=45450
X153 gnd! vdd! ICV_100 $T=127400 213200 1 0 $X=126500 $Y=201450
X154 gnd! vdd! ICV_100 $T=130200 254800 1 0 $X=129300 $Y=243050
X155 gnd! vdd! ICV_100 $T=131600 109200 1 0 $X=130700 $Y=97450
X156 gnd! vdd! ICV_100 $T=134400 109200 0 0 $X=133500 $Y=107850
X157 gnd! vdd! ICV_100 $T=134400 171600 1 0 $X=133500 $Y=159850
X158 gnd! vdd! ICV_100 $T=135800 192400 0 0 $X=134900 $Y=191050
X159 gnd! vdd! ICV_100 $T=197400 192400 0 0 $X=196500 $Y=191050
X160 gnd! vdd! ICV_100 $T=198800 234000 1 0 $X=197900 $Y=222250
X161 gnd! vdd! ICV_100 $T=221200 26000 1 0 $X=220300 $Y=14250
X162 gnd! vdd! ICV_100 $T=250600 26000 1 0 $X=249700 $Y=14250
X163 gnd! vdd! ICV_100 $T=254800 109200 1 0 $X=253900 $Y=97450
X164 gnd! vdd! ICV_100 $T=254800 150800 0 0 $X=253900 $Y=149450
X165 gnd! vdd! FILLCAPX2 $T=15400 46800 1 0 $X=14500 $Y=35050
X166 gnd! vdd! FILLCAPX2 $T=61600 26000 0 0 $X=60700 $Y=24650
X167 gnd! vdd! FILLCAPX2 $T=82600 192400 0 0 $X=81700 $Y=191050
X168 gnd! vdd! FILLCAPX2 $T=96600 254800 1 0 $X=95700 $Y=243050
X169 gnd! vdd! FILLCAPX2 $T=99400 88400 1 0 $X=98500 $Y=76650
X170 gnd! vdd! FILLCAPX2 $T=106400 109200 0 0 $X=105500 $Y=107850
X171 gnd! vdd! FILLCAPX2 $T=119000 109200 0 0 $X=118100 $Y=107850
X172 gnd! vdd! FILLCAPX2 $T=140000 46800 0 0 $X=139100 $Y=45450
X173 gnd! vdd! FILLCAPX2 $T=154000 88400 1 0 $X=153100 $Y=76650
X174 gnd! vdd! FILLCAPX2 $T=271600 109200 1 0 $X=270700 $Y=97450
X175 gnd! vdd! FILLCAPX2 $T=271600 130000 0 0 $X=270700 $Y=128650
X176 gnd! vdd! FILLCAPX2 $T=271600 150800 0 0 $X=270700 $Y=149450
X177 gnd! vdd! FILLCAPX32 $T=15400 213200 1 0 $X=14500 $Y=201450
X178 gnd! vdd! FILLCAPX32 $T=15400 213200 0 0 $X=14500 $Y=211850
X179 gnd! vdd! FILLCAPX32 $T=15400 234000 1 0 $X=14500 $Y=222250
X180 gnd! vdd! FILLCAPX32 $T=60200 234000 1 0 $X=59300 $Y=222250
X181 gnd! vdd! FILLCAPX32 $T=135800 192400 1 180 $X=90100 $Y=191050
X182 gnd! vdd! FILLCAPX32 $T=99400 26000 0 0 $X=98500 $Y=24650
X183 gnd! vdd! FILLCAPX32 $T=180600 213200 0 0 $X=179700 $Y=211850
X184 gnd! vdd! FILLCAPX16 $T=15400 109200 1 0 $X=14500 $Y=97450
X185 gnd! vdd! FILLCAPX16 $T=15400 109200 0 0 $X=14500 $Y=107850
X186 gnd! vdd! FILLCAPX16 $T=15400 130000 1 0 $X=14500 $Y=118250
X187 gnd! vdd! FILLCAPX16 $T=15400 130000 0 0 $X=14500 $Y=128650
X188 gnd! vdd! FILLCAPX16 $T=15400 150800 1 0 $X=14500 $Y=139050
X189 gnd! vdd! FILLCAPX16 $T=15400 171600 1 0 $X=14500 $Y=159850
X190 gnd! vdd! FILLCAPX16 $T=15400 171600 0 0 $X=14500 $Y=170250
X191 gnd! vdd! FILLCAPX16 $T=68600 46800 1 0 $X=67700 $Y=35050
X192 gnd! vdd! FILLCAPX16 $T=92400 26000 1 0 $X=91500 $Y=14250
X193 gnd! vdd! FILLCAPX16 $T=96600 130000 0 0 $X=95700 $Y=128650
X194 gnd! vdd! FILLCAPX16 $T=120400 46800 1 0 $X=119500 $Y=35050
X195 gnd! vdd! FILLCAPX16 $T=131600 88400 1 0 $X=130700 $Y=76650
X196 gnd! vdd! FILLCAPX16 $T=131600 150800 0 0 $X=130700 $Y=149450
X197 gnd! vdd! FILLCAPX16 $T=134400 88400 0 0 $X=133500 $Y=87050
X198 gnd! vdd! FILLCAPX16 $T=145600 26000 1 0 $X=144700 $Y=14250
X199 gnd! vdd! FILLCAPX16 $T=190400 213200 1 0 $X=189500 $Y=201450
X200 gnd! vdd! FILLCAPX16 $T=191800 192400 1 0 $X=190900 $Y=180650
X201 gnd! vdd! FILLCAPX16 $T=193200 67600 1 0 $X=192300 $Y=55850
X202 gnd! vdd! FILLCAPX16 $T=193200 171600 1 0 $X=192300 $Y=159850
X203 gnd! vdd! FILLCAPX16 $T=194600 150800 1 0 $X=193700 $Y=139050
X204 gnd! vdd! FILLCAPX16 $T=196000 88400 1 0 $X=195100 $Y=76650
X205 gnd! vdd! FILLCAPX16 $T=198800 26000 1 0 $X=197900 $Y=14250
X206 gnd! vdd! FILLCAPX16 $T=233800 150800 1 0 $X=232900 $Y=139050
X207 gnd! vdd! FILLCAPX16 $T=243600 213200 0 0 $X=242700 $Y=211850
X208 gnd! vdd! FILLCAPX16 $T=245000 109200 0 0 $X=244100 $Y=107850
X209 gnd! vdd! ICV_105 $T=15400 46800 0 0 $X=14500 $Y=45450
X210 gnd! vdd! ICV_105 $T=15400 150800 0 0 $X=14500 $Y=149450
X211 gnd! vdd! ICV_105 $T=15400 192400 1 0 $X=14500 $Y=180650
X212 gnd! vdd! ICV_105 $T=15400 192400 0 0 $X=14500 $Y=191050
X213 gnd! vdd! ICV_105 $T=15400 234000 0 0 $X=14500 $Y=232650
X214 gnd! vdd! ICV_105 $T=15400 254800 1 0 $X=14500 $Y=243050
X215 gnd! vdd! ICV_105 $T=60200 213200 1 0 $X=59300 $Y=201450
X216 gnd! vdd! ICV_105 $T=60200 213200 0 0 $X=59300 $Y=211850
X217 gnd! vdd! ICV_105 $T=152600 130000 0 0 $X=151700 $Y=128650
X297 45 40 fECG_gain<1> SPI_CS 34 128 gnd! vdd! DFCSX4 $T=21000 67600 0 0 $X=20150 $Y=66250
X298 45 41 fECG_gain<0> SPI_CS 34 129 gnd! vdd! DFCSX4 $T=21000 88400 1 0 $X=20150 $Y=76650
X299 45 31 fECG_gain<2> SPI_CS 34 130 gnd! vdd! DFCSX4 $T=26600 26000 0 0 $X=25750 $Y=24650
X300 45 51 fECG_BG_sel SPI_CS 34 137 gnd! vdd! DFCSX4 $T=50400 67600 1 0 $X=49550 $Y=55850
X301 45 66 fECG_filter<1> SPI_CS 34 134 gnd! vdd! DFCSX4 $T=99400 26000 1 180 $X=63550 $Y=24650
X302 70 77 33 35 44 51 gnd! vdd! DFCSX4 $T=64400 67600 0 0 $X=63550 $Y=66250
X303 60 ECG_gain<3> 51 SPI_CS 34 139 gnd! vdd! DFCSX4 $T=123200 46800 1 180 $X=87350 $Y=45450
X304 45 78 fECG_filter<0> SPI_CS 34 56 gnd! vdd! DFCSX4 $T=96600 109200 1 0 $X=95750 $Y=97450
X305 60 ECG_gain<1> 40 SPI_CS 34 65 gnd! vdd! DFCSX4 $T=135800 67600 1 180 $X=99950 $Y=66250
X306 60 ECG_filter<2> 29 SPI_CS 34 162 gnd! vdd! DFCSX4 $T=142800 46800 1 0 $X=141950 $Y=35050
X307 70 107 101 35 110 115 gnd! vdd! DFCSX4 $T=218400 213200 1 0 $X=217550 $Y=201450
X308 70 124 102 35 110 173 gnd! vdd! DFCSX4 $T=218400 254800 1 0 $X=217550 $Y=243050
X309 70 104 109 35 110 117 gnd! vdd! DFCSX4 $T=219800 130000 0 0 $X=218950 $Y=128650
X310 45 117 Bio_Calib_EN SPI_CS 34 175 gnd! vdd! DFCSX4 $T=225400 130000 1 0 $X=224550 $Y=118250
X311 gnd! vdd! 45 29 fECG_filter<2> SPI_CS 34 30 ICV_103 $T=18200 46800 1 0 $X=17350 $Y=35050
X312 gnd! vdd! 70 36 42 35 44 40 ICV_103 $T=43400 109200 1 0 $X=42550 $Y=97450
X313 gnd! vdd! 70 42 29 35 44 41 ICV_103 $T=43400 109200 0 0 $X=42550 $Y=107850
X314 gnd! vdd! 60 ECG_gain<0> 41 SPI_CS 34 153 ICV_103 $T=95200 88400 0 0 $X=94350 $Y=87050
X315 gnd! vdd! 60 ECG_filter<1> 66 SPI_CS 34 163 ICV_103 $T=142800 46800 0 0 $X=141950 $Y=45450
X316 gnd! vdd! 70 89 71 35 44 82 ICV_103 $T=151200 109200 0 0 $X=150350 $Y=107850
X317 gnd! vdd! 70 91 74 35 44 164 ICV_103 $T=152600 171600 0 0 $X=151750 $Y=170250
X318 gnd! vdd! 70 92 72 35 44 166 ICV_103 $T=154000 150800 0 0 $X=153150 $Y=149450
X319 gnd! vdd! 60 ECG_filter<0> 78 SPI_CS 34 165 ICV_103 $T=156800 88400 1 0 $X=155950 $Y=76650
X320 gnd! vdd! 70 99 77 35 44 105 ICV_103 $T=168000 67600 0 0 $X=167150 $Y=66250
X321 gnd! vdd! 60 ECG_BG_sel 105 SPI_CS 34 94 ICV_103 $T=172200 26000 0 0 $X=171350 $Y=24650
X322 gnd! vdd! 45 121 Bio_Gain<3> SPI_CS 34 96 ICV_103 $T=187600 46800 0 0 $X=186750 $Y=45450
X323 gnd! vdd! 70 123 100 35 110 172 ICV_103 $T=214200 192400 1 0 $X=213350 $Y=180650
X324 gnd! vdd! 45 114 Bio_Gain<1> SPI_CS 34 174 ICV_103 $T=224000 67600 1 0 $X=223150 $Y=55850
X325 gnd! vdd! 45 105 Bio_Gain<0> SPI_CS 34 127 ICV_103 $T=225400 26000 0 0 $X=224550 $Y=24650
X354 130 gnd! fECG_gain<2> vdd! CLKBUFX16 $T=44800 26000 0 180 $X=34150 $Y=14250
X355 128 gnd! fECG_gain<1> vdd! CLKBUFX16 $T=44800 67600 0 180 $X=34150 $Y=55850
X356 129 gnd! fECG_gain<0> vdd! CLKBUFX16 $T=54600 88400 1 180 $X=43950 $Y=87050
X357 30 gnd! fECG_filter<2> vdd! CLKBUFX16 $T=58800 46800 1 0 $X=57950 $Y=35050
X358 134 gnd! fECG_filter<1> vdd! CLKBUFX16 $T=74200 26000 1 0 $X=73350 $Y=14250
X359 137 gnd! fECG_BG_sel vdd! CLKBUFX16 $T=86800 67600 1 0 $X=85950 $Y=55850
X360 54 gnd! 110 vdd! CLKBUFX16 $T=103600 234000 0 0 $X=102750 $Y=232650
X361 139 gnd! ECG_gain<3> vdd! CLKBUFX16 $T=106400 46800 1 0 $X=105550 $Y=35050
X362 56 gnd! fECG_filter<0> vdd! CLKBUFX16 $T=109200 109200 0 0 $X=108350 $Y=107850
X363 153 gnd! ECG_gain<0> vdd! CLKBUFX16 $T=123200 88400 0 180 $X=112550 $Y=76650
X364 67 gnd! ECG_gain<2> vdd! CLKBUFX16 $T=128800 26000 1 0 $X=127950 $Y=14250
X365 65 gnd! ECG_gain<1> vdd! CLKBUFX16 $T=149800 67600 1 180 $X=139150 $Y=66250
X366 162 gnd! ECG_filter<2> vdd! CLKBUFX16 $T=166600 26000 1 180 $X=155950 $Y=24650
X367 163 gnd! ECG_filter<1> vdd! CLKBUFX16 $T=179200 46800 1 0 $X=178350 $Y=35050
X368 165 gnd! ECG_filter<0> vdd! CLKBUFX16 $T=189000 67600 0 180 $X=178350 $Y=55850
X369 94 gnd! ECG_BG_sel vdd! CLKBUFX16 $T=189000 26000 1 0 $X=188150 $Y=14250
X370 96 gnd! Bio_Gain<3> vdd! CLKBUFX16 $T=210000 46800 0 180 $X=199350 $Y=35050
X371 106 gnd! Bio_Ptat_EN vdd! CLKBUFX16 $T=212800 109200 0 180 $X=202150 $Y=97450
X372 126 gnd! Bio_Gain<2> vdd! CLKBUFX16 $T=222600 46800 0 180 $X=211950 $Y=35050
X373 127 gnd! Bio_Gain<0> vdd! CLKBUFX16 $T=240800 26000 1 0 $X=239950 $Y=14250
X374 174 gnd! Bio_Gain<1> vdd! CLKBUFX16 $T=253400 46800 0 180 $X=242750 $Y=35050
X375 175 gnd! Bio_Calib_EN vdd! CLKBUFX16 $T=266000 130000 1 180 $X=255350 $Y=128650
X376 gnd! vdd! ICV_97 $T=37800 130000 1 0 $X=36900 $Y=118250
X377 gnd! vdd! ICV_97 $T=37800 171600 0 0 $X=36900 $Y=170250
X378 gnd! vdd! ICV_97 $T=56000 67600 0 0 $X=55100 $Y=66250
X379 gnd! vdd! ICV_97 $T=58800 26000 1 0 $X=57900 $Y=14250
X380 gnd! vdd! ICV_97 $T=105000 234000 1 0 $X=104100 $Y=222250
X381 gnd! vdd! ICV_97 $T=109200 192400 1 0 $X=108300 $Y=180650
X382 gnd! vdd! ICV_97 $T=110600 130000 1 0 $X=109700 $Y=118250
X383 gnd! vdd! ICV_97 $T=114800 171600 0 0 $X=113900 $Y=170250
X384 gnd! vdd! ICV_97 $T=135800 234000 0 0 $X=134900 $Y=232650
X385 gnd! vdd! ICV_97 $T=189000 46800 1 0 $X=188100 $Y=35050
X386 gnd! vdd! ICV_97 $T=190400 109200 1 0 $X=189500 $Y=97450
X387 gnd! vdd! ICV_97 $T=215600 67600 1 0 $X=214700 $Y=55850
X388 gnd! vdd! ICV_97 $T=266000 213200 0 0 $X=265100 $Y=211850
X389 gnd! vdd! ICV_98 $T=37800 171600 1 0 $X=36900 $Y=159850
X390 gnd! vdd! ICV_98 $T=82600 109200 1 0 $X=81700 $Y=97450
X391 gnd! vdd! ICV_98 $T=114800 26000 1 0 $X=113900 $Y=14250
X392 gnd! vdd! ICV_98 $T=134400 192400 1 0 $X=133500 $Y=180650
X393 gnd! vdd! ICV_98 $T=135800 130000 1 0 $X=134900 $Y=118250
X394 gnd! vdd! ICV_98 $T=154000 67600 0 0 $X=153100 $Y=66250
X395 gnd! vdd! ICV_98 $T=211400 26000 0 0 $X=210500 $Y=24650
X396 gnd! vdd! ICV_98 $T=256200 88400 0 0 $X=255300 $Y=87050
X397 gnd! vdd! ICV_98 $T=256200 150800 1 0 $X=255300 $Y=139050
X398 gnd! vdd! ICV_98 $T=260400 130000 1 0 $X=259500 $Y=118250
X399 gnd! vdd! ICV_98 $T=260400 171600 1 0 $X=259500 $Y=159850
X400 gnd! vdd! ICV_98 $T=260400 192400 1 0 $X=259500 $Y=180650
X401 35 131 47 133 gnd! vdd! 199 DFCX4 $T=49000 130000 1 0 $X=48150 $Y=118250
X402 35 43 47 136 gnd! vdd! 200 DFCX4 $T=81200 130000 1 0 $X=80350 $Y=118250
X403 35 140 47 49 gnd! vdd! 145 DFCX4 $T=85400 150800 0 0 $X=84550 $Y=149450
X404 35 48 47 142 gnd! vdd! 201 DFCX4 $T=85400 171600 0 0 $X=84550 $Y=170250
X405 35 61 47 150 gnd! vdd! 202 DFCX4 $T=152600 171600 1 180 $X=122350 $Y=170250
X406 gnd! vdd! ICV_96 $T=54600 130000 0 0 $X=53700 $Y=128650
X407 gnd! vdd! ICV_96 $T=54600 150800 1 0 $X=53700 $Y=139050
X408 gnd! vdd! ICV_96 $T=78400 171600 0 0 $X=77500 $Y=170250
X409 gnd! vdd! ICV_96 $T=82600 254800 1 0 $X=81700 $Y=243050
X410 gnd! vdd! ICV_96 $T=207200 171600 0 0 $X=206300 $Y=170250
X411 gnd! vdd! ICV_96 $T=225400 213200 0 0 $X=224500 $Y=211850
X412 gnd! vdd! ICV_96 $T=267400 26000 1 0 $X=266500 $Y=14250
X413 gnd! vdd! ICV_96 $T=267400 109200 0 0 $X=266500 $Y=107850
X414 133 vdd! gnd! 32 CLKBUFX4 $T=65800 150800 1 0 $X=64950 $Y=139050
X415 90 vdd! gnd! 63 CLKBUFX4 $T=102200 254800 1 0 $X=101350 $Y=243050
X416 144 vdd! gnd! 146 CLKBUFX4 $T=106400 254800 1 0 $X=105550 $Y=243050
X417 186 vdd! gnd! 143 CLKBUFX4 $T=110600 150800 1 0 $X=109750 $Y=139050
X418 55 vdd! gnd! 144 CLKBUFX4 $T=110600 254800 1 0 $X=109750 $Y=243050
X419 147 vdd! gnd! 188 CLKBUFX4 $T=113400 234000 0 0 $X=112550 $Y=232650
X420 188 vdd! gnd! 148 CLKBUFX4 $T=117600 234000 0 0 $X=116750 $Y=232650
X421 58 vdd! gnd! 61 CLKBUFX4 $T=121800 192400 1 0 $X=120950 $Y=180650
X422 53 vdd! gnd! 151 CLKBUFX4 $T=126000 234000 1 0 $X=125150 $Y=222250
X423 64 vdd! gnd! 193 CLKBUFX4 $T=130200 213200 0 0 $X=129350 $Y=211850
X424 193 vdd! gnd! 156 CLKBUFX4 $T=145600 213200 0 0 $X=144750 $Y=211850
X425 156 vdd! gnd! 159 CLKBUFX4 $T=147000 213200 1 0 $X=146150 $Y=201450
X426 158 vdd! gnd! 157 CLKBUFX4 $T=147000 234000 1 0 $X=146150 $Y=222250
X427 76 vdd! gnd! 158 CLKBUFX4 $T=147000 234000 0 0 $X=146150 $Y=232650
X428 81 vdd! gnd! 68 CLKBUFX4 $T=147000 254800 1 0 $X=146150 $Y=243050
X429 157 vdd! gnd! 64 CLKBUFX4 $T=149800 213200 0 0 $X=148950 $Y=211850
X430 159 vdd! gnd! 69 CLKBUFX4 $T=154000 213200 0 0 $X=153150 $Y=211850
X431 164 vdd! gnd! 91 CLKBUFX4 $T=191800 171600 0 0 $X=190950 $Y=170250
X432 gnd! vdd! 39 132 ICV_99 $T=56000 171600 1 0 $X=55150 $Y=159850
X433 gnd! vdd! 41 42 ICV_99 $T=82600 109200 0 0 $X=81750 $Y=107850
X434 gnd! vdd! 95 59 ICV_99 $T=128800 234000 0 0 $X=127950 $Y=232650
X435 gnd! vdd! 87 88 ICV_99 $T=190400 192400 0 0 $X=189550 $Y=191050
X436 gnd! vdd! 169 167 ICV_99 $T=191800 234000 1 0 $X=190950 $Y=222250
X437 gnd! vdd! 166 92 ICV_99 $T=193200 150800 0 0 $X=192350 $Y=149450
X438 gnd! vdd! 117 104 ICV_99 $T=226800 150800 1 0 $X=225950 $Y=139050
X439 gnd! vdd! 116 108 ICV_99 $T=236600 213200 0 0 $X=235750 $Y=211850
X440 gnd! vdd! 171 122 ICV_99 $T=253400 171600 1 0 $X=252550 $Y=159850
X441 gnd! vdd! 172 123 ICV_99 $T=253400 192400 1 0 $X=252550 $Y=180650
X442 gnd! vdd! 120 125 ICV_99 $T=256200 88400 1 0 $X=255350 $Y=76650
X443 gnd! vdd! 70 33 36 35 44 31 31 33 ICV_104 $T=60200 88400 1 0 $X=59350 $Y=76650
X444 gnd! vdd! 70 52 89 35 44 62 62 52 ICV_104 $T=114800 150800 1 0 $X=113950 $Y=139050
X445 gnd! vdd! 70 75 78 35 44 66 66 75 ICV_104 $T=151200 109200 1 0 $X=150350 $Y=97450
X446 gnd! vdd! 70 73 160 35 110 79 79 73 ICV_104 $T=151200 213200 1 0 $X=150350 $Y=201450
X447 gnd! vdd! 70 160 68 35 110 80 80 160 ICV_104 $T=151200 234000 1 0 $X=150350 $Y=222250
X448 gnd! vdd! 93 68 124 35 110 81 63 70 ICV_104 $T=151200 254800 1 0 $X=150350 $Y=243050
X449 gnd! vdd! 70 74 88 35 110 83 83 74 ICV_104 $T=152600 192400 1 0 $X=151750 $Y=180650
X450 gnd! vdd! 70 71 161 35 44 85 85 71 ICV_104 $T=154000 130000 1 0 $X=153150 $Y=118250
X451 gnd! vdd! 70 72 91 35 44 84 84 72 ICV_104 $T=154000 171600 1 0 $X=153150 $Y=159850
X452 gnd! vdd! 70 161 92 35 44 86 86 161 ICV_104 $T=155400 150800 1 0 $X=154550 $Y=139050
X453 gnd! vdd! 70 103 99 35 44 114 114 103 ICV_104 $T=214200 67600 0 0 $X=213350 $Y=66250
X454 gnd! vdd! 70 100 122 35 44 111 111 100 ICV_104 $T=214200 171600 0 0 $X=213350 $Y=170250
X455 gnd! vdd! 70 101 123 35 110 112 112 101 ICV_104 $T=214200 192400 0 0 $X=213350 $Y=191050
X456 gnd! vdd! 70 102 108 35 110 113 113 102 ICV_104 $T=214200 234000 0 0 $X=213350 $Y=232650
X457 gnd! vdd! 70 97 104 35 110 119 119 97 ICV_104 $T=215600 150800 0 0 $X=214750 $Y=149450
X458 gnd! vdd! 70 98 125 35 44 121 121 98 ICV_104 $T=217000 88400 0 0 $X=216150 $Y=87050
X459 38 vdd! 131 135 gnd! NOR2X3 $T=61600 130000 0 0 $X=60750 $Y=128650
X460 37 vdd! 38 32 gnd! NOR2X3 $T=61600 150800 1 0 $X=60750 $Y=139050
X461 37 133 gnd! vdd! 135 AND2X4 $T=70000 130000 0 0 $X=69150 $Y=128650
X462 146 reset_l gnd! vdd! 147 AND2X4 $T=114800 254800 1 0 $X=113950 $Y=243050
X463 40 vdd! gnd! 36 CLKBUFX2 $T=71400 88400 0 0 $X=70550 $Y=87050
X464 90 vdd! gnd! 186 CLKBUFX2 $T=106400 150800 1 0 $X=105550 $Y=139050
X465 SPI_CS vdd! gnd! 168 CLKBUFX2 $T=187600 234000 0 0 $X=186750 $Y=232650
X466 167 vdd! gnd! 90 CLKBUFX2 $T=191800 234000 0 0 $X=190950 $Y=232650
X467 105 vdd! gnd! 99 CLKBUFX2 $T=207200 67600 0 0 $X=206350 $Y=66250
X468 115 vdd! gnd! 107 CLKBUFX2 $T=232400 213200 0 0 $X=231550 $Y=211850
X469 118 vdd! gnd! 109 CLKBUFX2 $T=238000 109200 0 0 $X=237150 $Y=107850
X470 173 vdd! gnd! 124 CLKBUFX2 $T=253400 254800 1 0 $X=252550 $Y=243050
X471 135 136 46 vdd! gnd! 43 HAX3 $T=74200 150800 1 0 $X=73350 $Y=139050
X472 46 49 141 vdd! gnd! 140 HAX3 $T=100800 150800 0 180 $X=87350 $Y=139050
X473 141 142 57 vdd! gnd! 48 HAX3 $T=93800 192400 1 0 $X=92950 $Y=180650
X476 gnd! vdd! ICV_101 $T=82600 234000 0 0 $X=81700 $Y=232650
X477 gnd! vdd! ICV_101 $T=168000 26000 1 0 $X=167100 $Y=14250
X478 gnd! vdd! ICV_101 $T=253400 67600 0 0 $X=252500 $Y=66250
X479 gnd! vdd! ICV_101 $T=253400 171600 0 0 $X=252500 $Y=170250
X480 gnd! vdd! ICV_101 $T=253400 192400 0 0 $X=252500 $Y=191050
X481 gnd! vdd! ICV_101 $T=253400 213200 1 0 $X=252500 $Y=201450
X482 gnd! vdd! ICV_101 $T=253400 234000 1 0 $X=252500 $Y=222250
X483 gnd! vdd! ICV_101 $T=253400 234000 0 0 $X=252500 $Y=232650
X484 38 vdd! gnd! 50 CLKINVX1 $T=89600 130000 0 0 $X=88750 $Y=128650
X485 62 vdd! gnd! 149 CLKINVX1 $T=128800 150800 1 180 $X=125150 $Y=149450
X486 155 vdd! gnd! 154 CLKINVX1 $T=130200 130000 1 0 $X=129350 $Y=118250
X487 51 vdd! gnd! 77 CLKBUFX3 $T=96600 67600 1 0 $X=95750 $Y=55850
X488 148 vdd! gnd! 152 CLKBUFX3 $T=120400 234000 1 0 $X=119550 $Y=222250
X489 82 vdd! gnd! 89 CLKBUFX3 $T=190400 109200 0 0 $X=189550 $Y=107850
X490 gnd! vdd! 60 ECG_gain<2> 31 SPI_CS 34 67 ICV_102 $T=120400 67600 1 0 $X=119500 $Y=55850
X491 gnd! vdd! 70 88 73 35 110 87 ICV_102 $T=152600 192400 0 0 $X=151700 $Y=191050
X492 gnd! vdd! 45 118 Bio_Ptat_EN SPI_CS 34 106 ICV_102 $T=198800 109200 0 0 $X=197900 $Y=107850
X493 gnd! vdd! 70 122 97 35 110 171 ICV_102 $T=215600 171600 1 0 $X=214700 $Y=159850
X494 gnd! vdd! 70 108 107 35 110 116 ICV_102 $T=215600 234000 1 0 $X=214700 $Y=222250
X495 gnd! vdd! 70 109 98 35 44 118 ICV_102 $T=217000 109200 1 0 $X=216100 $Y=97450
X496 gnd! vdd! 70 125 103 35 44 120 ICV_102 $T=218400 88400 1 0 $X=217500 $Y=76650
X497 gnd! vdd! 45 120 Bio_Gain<2> SPI_CS 34 126 ICV_102 $T=226800 46800 0 0 $X=225900 $Y=45450
X498 porborn gnd! 55 vdd! BUFX16 $T=120400 254800 1 0 $X=119550 $Y=243050
X499 SPI_MOSI gnd! 194 vdd! BUFX16 $T=158200 213200 0 0 $X=157350 $Y=211850
X500 151 54 gnd! vdd! CLKBUFX8 $T=121800 234000 0 0 $X=120950 $Y=232650
X501 194 76 gnd! vdd! CLKBUFX8 $T=175000 213200 0 0 $X=174150 $Y=211850
X502 95 170 gnd! vdd! CLKBUFX8 $T=222600 130000 0 180 $X=216150 $Y=118250
X503 70 78 69 35 110 78 vdd! gnd! DFCSX2 $T=151200 234000 0 0 $X=150350 $Y=232650
X504 70 29 75 35 44 29 vdd! gnd! DFCSX2 $T=162400 88400 0 0 $X=161550 $Y=87050
X505 168 gnd! 169 vdd! CLKBUFX24 $T=196000 234000 0 0 $X=195150 $Y=232650
X506 34 gnd! 44 vdd! CLKBUFX24 $T=197400 130000 1 0 $X=196550 $Y=118250
.ENDS
***************************************
.SUBCKT P1_C_CDNS_78073660103204
** N=2 EP=0 IP=0 FDC=0
.ENDS
***************************************
.SUBCKT PD_C_CDNS_78073660103520
** N=1 EP=0 IP=0 FDC=0
.ENDS
***************************************
.SUBCKT P1_C_CDNS_78073660103500
** N=2 EP=0 IP=0 FDC=0
.ENDS
***************************************
.SUBCKT ICV_65 3 24 25 26 27 28 29 30 31 32 33 34 35 36 37 38 39 42
** N=42 EP=18 IP=52 FDC=10
M0 3 3 3 42 nmos4 L=2e-05 W=2e-06 AD=1.7e-12 AS=1.7e-12 PD=3.7e-06 PS=3.7e-06 NRD=0.2125 NRS=0.2125 $X=0 $Y=850 $D=38
M1 3 3 3 42 nmos4 L=2e-05 W=2e-06 AD=1.7e-12 AS=1.7e-12 PD=3.7e-06 PS=3.7e-06 NRD=0.2125 NRS=0.2125 $X=68250 $Y=850 $D=38
M2 25 3 24 42 nmos4 L=2e-05 W=2e-06 AD=1.7e-12 AS=1.7e-12 PD=3.7e-06 PS=3.7e-06 NRD=0.2125 NRS=0.2125 $X=22750 $Y=850 $D=37
M3 27 3 26 42 nmos4 L=2e-05 W=2e-06 AD=1.7e-12 AS=1.7e-12 PD=3.7e-06 PS=3.7e-06 NRD=0.2125 NRS=0.2125 $X=26000 $Y=850 $D=37
M4 29 3 28 42 nmos4 L=2e-05 W=2e-06 AD=1.7e-12 AS=1.7e-12 PD=3.7e-06 PS=3.7e-06 NRD=0.2125 NRS=0.2125 $X=29250 $Y=850 $D=37
M5 31 3 30 42 nmos4 L=2e-05 W=2e-06 AD=1.7e-12 AS=1.7e-12 PD=3.7e-06 PS=3.7e-06 NRD=0.2125 NRS=0.2125 $X=32500 $Y=850 $D=37
M6 33 3 32 42 nmos4 L=2e-05 W=2e-06 AD=1.7e-12 AS=1.7e-12 PD=3.7e-06 PS=3.7e-06 NRD=0.2125 NRS=0.2125 $X=35750 $Y=850 $D=37
M7 35 3 34 42 nmos4 L=2e-05 W=2e-06 AD=1.7e-12 AS=1.7e-12 PD=3.7e-06 PS=3.7e-06 NRD=0.2125 NRS=0.2125 $X=39000 $Y=850 $D=37
M8 37 3 36 42 nmos4 L=2e-05 W=2e-06 AD=1.7e-12 AS=1.7e-12 PD=3.7e-06 PS=3.7e-06 NRD=0.2125 NRS=0.2125 $X=42250 $Y=850 $D=37
M9 39 3 38 42 nmos4 L=2e-05 W=2e-06 AD=1.7e-12 AS=1.7e-12 PD=3.7e-06 PS=3.7e-06 NRD=0.2125 NRS=0.2125 $X=45500 $Y=850 $D=37
.ENDS
***************************************
.SUBCKT PD_C_CDNS_78073660103522
** N=1 EP=0 IP=0 FDC=0
.ENDS
***************************************
.SUBCKT ND_C_CDNS_78073660103506
** N=2 EP=0 IP=0 FDC=0
.ENDS
***************************************
.SUBCKT cpolyc_CDNS_78073660103149 1 2
** N=2 EP=2 IP=0 FDC=1
C0 1 2 $[cpolya] $A=11583 $P=430.5 $X=1800 $Y=1000 $D=58
.ENDS
***************************************
.SUBCKT cpolyc_CDNS_78073660103148 1 2
** N=2 EP=2 IP=0 FDC=1
C0 1 2 $[cpolya] $A=3466.12 $P=235.5 $X=1800 $Y=1000 $D=58
.ENDS
***************************************
.SUBCKT cpolyc_CDNS_78073660103147 1 2
** N=2 EP=2 IP=0 FDC=1
C0 1 2 $[cpolya] $A=4277 $P=261.6 $X=1800 $Y=1000 $D=58
.ENDS
***************************************
.SUBCKT cpolyc_CDNS_78073660103145 1 2
** N=2 EP=2 IP=0 FDC=1
C0 1 2 $[cpolya] $A=3500 $P=240 $X=1800 $Y=1000 $D=58
.ENDS
***************************************
.SUBCKT ICV_61 1 2
*.CALIBRE ICV_CELL 9
** N=2 EP=2 IP=4 FDC=2
X0 1 2 cpolyc_CDNS_78073660103145 $T=0 0 0 0 $X=-1350 $Y=-1350
X1 1 2 cpolyc_CDNS_78073660103145 $T=76500 0 0 0 $X=75150 $Y=-1350
.ENDS
***************************************
.SUBCKT Gm_C_filter 1 2 VDDA 4 5 BIAS 7 OUT S<0> 10 11 12 GNDA INP INN S<1> S<2>
** N=171 EP=17 IP=813 FDC=464
R0 2 1 L=0.00194965 W=2e-06 $[rpolyh] $X=284375 $Y=-260100 $D=18
D1 GNDA VDDA p_nwd AREA=6385.26 PJ=361 $X=30275 $Y=-98150 $D=87
D2 GNDA 2 p_nwd AREA=609 PJ=104.8 $X=190800 $Y=-78200 $D=87
D3 GNDA 1 p_nwd AREA=599.43 PJ=103.7 $X=191400 $Y=-102300 $D=87
D4 GNDA 1 p_nwd AREA=598.56 PJ=103.6 $X=230950 $Y=-78200 $D=87
D5 GNDA 2 p_nwd AREA=595.08 PJ=103.2 $X=231200 $Y=-102300 $D=87
D6 GNDA VDDA p_nwd AREA=1316.46 PJ=148.1 $X=282925 $Y=-76700 $D=87
D7 GNDA VDDA p_nwd AREA=97.8125 PJ=43.8 $X=333550 $Y=-60700 $D=87
M8 20 20 20 GNDA nmos4 L=1e-05 W=2e-06 AD=1.7e-12 AS=1.7e-12 PD=3.7e-06 PS=3.7e-06 NRD=0.2125 NRS=0.2125 $X=65625 $Y=-181350 $D=38
M9 20 20 20 GNDA nmos4 L=1e-05 W=2e-06 AD=1.7e-12 AS=1.7e-12 PD=3.7e-06 PS=3.7e-06 NRD=0.2125 NRS=0.2125 $X=68875 $Y=-181350 $D=38
M10 20 20 20 GNDA nmos4 L=1e-05 W=2e-06 AD=1.7e-12 AS=1.7e-12 PD=3.7e-06 PS=3.7e-06 NRD=0.2125 NRS=0.2125 $X=72125 $Y=-181350 $D=38
M11 20 20 20 GNDA nmos4 L=1e-05 W=2e-06 AD=1.7e-12 AS=1.7e-12 PD=3.7e-06 PS=3.7e-06 NRD=0.2125 NRS=0.2125 $X=75375 $Y=-181350 $D=38
M12 20 20 20 GNDA nmos4 L=1e-05 W=2e-06 AD=1.7e-12 AS=1.7e-12 PD=3.7e-06 PS=3.7e-06 NRD=0.2125 NRS=0.2125 $X=78625 $Y=-212950 $D=38
M13 20 20 20 GNDA nmos4 L=1e-05 W=2e-06 AD=1.7e-12 AS=1.7e-12 PD=3.7e-06 PS=3.7e-06 NRD=0.2125 NRS=0.2125 $X=78625 $Y=-197150 $D=38
M14 20 20 20 GNDA nmos4 L=1e-05 W=2e-06 AD=1.7e-12 AS=1.7e-12 PD=3.7e-06 PS=3.7e-06 NRD=0.2125 NRS=0.2125 $X=78625 $Y=-181350 $D=38
M15 20 20 20 GNDA nmos4 L=1e-05 W=2e-06 AD=1.7e-12 AS=1.7e-12 PD=3.7e-06 PS=3.7e-06 NRD=0.2125 NRS=0.2125 $X=78625 $Y=-165550 $D=38
M16 4 4 4 GNDA nmos4 L=2e-05 W=2e-06 AD=1.7e-12 AS=1.7e-12 PD=3.7e-06 PS=3.7e-06 NRD=0.2125 NRS=0.2125 $X=115250 $Y=-259200 $D=38
M17 4 4 4 GNDA nmos4 L=2e-05 W=2e-06 AD=1.7e-12 AS=1.7e-12 PD=3.7e-06 PS=3.7e-06 NRD=0.2125 NRS=0.2125 $X=118500 $Y=-259200 $D=38
M18 4 4 4 GNDA nmos4 L=2e-05 W=2e-06 AD=1.7e-12 AS=1.7e-12 PD=3.7e-06 PS=3.7e-06 NRD=0.2125 NRS=0.2125 $X=121750 $Y=-259200 $D=38
M19 4 4 4 GNDA nmos4 L=2e-05 W=2e-06 AD=1.7e-12 AS=1.7e-12 PD=3.7e-06 PS=3.7e-06 NRD=0.2125 NRS=0.2125 $X=125000 $Y=-259200 $D=38
M20 4 4 4 GNDA nmos4 L=2e-05 W=2e-06 AD=1.7e-12 AS=1.7e-12 PD=3.7e-06 PS=3.7e-06 NRD=0.2125 NRS=0.2125 $X=128250 $Y=-259200 $D=38
M21 4 4 4 GNDA nmos4 L=2e-05 W=2e-06 AD=1.7e-12 AS=1.7e-12 PD=3.7e-06 PS=3.7e-06 NRD=0.2125 NRS=0.2125 $X=131500 $Y=-259200 $D=38
M22 4 4 4 GNDA nmos4 L=2e-05 W=2e-06 AD=1.7e-12 AS=1.7e-12 PD=3.7e-06 PS=3.7e-06 NRD=0.2125 NRS=0.2125 $X=160750 $Y=-259200 $D=38
M23 4 4 4 GNDA nmos4 L=2e-05 W=2e-06 AD=1.7e-12 AS=1.7e-12 PD=3.7e-06 PS=3.7e-06 NRD=0.2125 NRS=0.2125 $X=164000 $Y=-259200 $D=38
M24 4 4 4 GNDA nmos4 L=2e-05 W=2e-06 AD=1.7e-12 AS=1.7e-12 PD=3.7e-06 PS=3.7e-06 NRD=0.2125 NRS=0.2125 $X=167250 $Y=-259200 $D=38
M25 4 4 4 GNDA nmos4 L=2e-05 W=2e-06 AD=1.7e-12 AS=1.7e-12 PD=3.7e-06 PS=3.7e-06 NRD=0.2125 NRS=0.2125 $X=170500 $Y=-259200 $D=38
M26 4 4 4 GNDA nmos4 L=2e-05 W=2e-06 AD=1.7e-12 AS=1.7e-12 PD=3.7e-06 PS=3.7e-06 NRD=0.2125 NRS=0.2125 $X=173750 $Y=-259200 $D=38
M27 4 4 4 GNDA nmos4 L=2e-05 W=2e-06 AD=1.7e-12 AS=1.7e-12 PD=3.7e-06 PS=3.7e-06 NRD=0.2125 NRS=0.2125 $X=177000 $Y=-259200 $D=38
M28 5 5 5 GNDA nmos4 L=2e-05 W=2e-06 AD=1.7e-12 AS=1.7e-12 PD=3.7e-06 PS=3.7e-06 NRD=0.2125 NRS=0.2125 $X=204025 $Y=-258400 $D=38
M29 5 5 5 GNDA nmos4 L=2e-05 W=2e-06 AD=1.7e-12 AS=1.7e-12 PD=3.7e-06 PS=3.7e-06 NRD=0.2125 NRS=0.2125 $X=207275 $Y=-258400 $D=38
M30 5 5 5 GNDA nmos4 L=2e-05 W=2e-06 AD=1.7e-12 AS=1.7e-12 PD=3.7e-06 PS=3.7e-06 NRD=0.2125 NRS=0.2125 $X=210525 $Y=-258400 $D=38
M31 5 5 5 GNDA nmos4 L=2e-05 W=2e-06 AD=1.7e-12 AS=1.7e-12 PD=3.7e-06 PS=3.7e-06 NRD=0.2125 NRS=0.2125 $X=213775 $Y=-258400 $D=38
M32 5 5 5 GNDA nmos4 L=2e-05 W=2e-06 AD=1.7e-12 AS=1.7e-12 PD=3.7e-06 PS=3.7e-06 NRD=0.2125 NRS=0.2125 $X=217025 $Y=-258400 $D=38
M33 5 5 5 GNDA nmos4 L=2e-05 W=2e-06 AD=1.7e-12 AS=1.7e-12 PD=3.7e-06 PS=3.7e-06 NRD=0.2125 NRS=0.2125 $X=220275 $Y=-258400 $D=38
M34 5 5 5 GNDA nmos4 L=2e-05 W=2e-06 AD=1.7e-12 AS=1.7e-12 PD=3.7e-06 PS=3.7e-06 NRD=0.2125 NRS=0.2125 $X=249525 $Y=-258400 $D=38
M35 5 5 5 GNDA nmos4 L=2e-05 W=2e-06 AD=1.7e-12 AS=1.7e-12 PD=3.7e-06 PS=3.7e-06 NRD=0.2125 NRS=0.2125 $X=252775 $Y=-258400 $D=38
M36 5 5 5 GNDA nmos4 L=2e-05 W=2e-06 AD=1.7e-12 AS=1.7e-12 PD=3.7e-06 PS=3.7e-06 NRD=0.2125 NRS=0.2125 $X=256025 $Y=-258400 $D=38
M37 5 5 5 GNDA nmos4 L=2e-05 W=2e-06 AD=1.7e-12 AS=1.7e-12 PD=3.7e-06 PS=3.7e-06 NRD=0.2125 NRS=0.2125 $X=259275 $Y=-258400 $D=38
M38 5 5 5 GNDA nmos4 L=2e-05 W=2e-06 AD=1.7e-12 AS=1.7e-12 PD=3.7e-06 PS=3.7e-06 NRD=0.2125 NRS=0.2125 $X=262525 $Y=-258400 $D=38
M39 5 5 5 GNDA nmos4 L=2e-05 W=2e-06 AD=1.7e-12 AS=1.7e-12 PD=3.7e-06 PS=3.7e-06 NRD=0.2125 NRS=0.2125 $X=265775 $Y=-258400 $D=38
M40 30 20 34 GNDA nmos4 L=1e-05 W=2e-06 AD=1.7e-12 AS=1.7e-12 PD=3.7e-06 PS=3.7e-06 NRD=0.2125 NRS=0.2125 $X=62375 $Y=-212950 $D=37
M41 31 20 35 GNDA nmos4 L=1e-05 W=2e-06 AD=1.7e-12 AS=1.7e-12 PD=3.7e-06 PS=3.7e-06 NRD=0.2125 NRS=0.2125 $X=62375 $Y=-197150 $D=37
M42 20 20 32 GNDA nmos4 L=1e-05 W=2e-06 AD=1.7e-12 AS=1.7e-12 PD=3.7e-06 PS=3.7e-06 NRD=0.2125 NRS=0.2125 $X=62375 $Y=-181350 $D=37
M43 33 20 36 GNDA nmos4 L=1e-05 W=2e-06 AD=1.7e-12 AS=1.7e-12 PD=3.7e-06 PS=3.7e-06 NRD=0.2125 NRS=0.2125 $X=62375 $Y=-165550 $D=37
M44 30 20 34 GNDA nmos4 L=1e-05 W=2e-06 AD=1.7e-12 AS=1.7e-12 PD=3.7e-06 PS=3.7e-06 NRD=0.2125 NRS=0.2125 $X=65625 $Y=-212950 $D=37
M45 31 20 35 GNDA nmos4 L=1e-05 W=2e-06 AD=1.7e-12 AS=1.7e-12 PD=3.7e-06 PS=3.7e-06 NRD=0.2125 NRS=0.2125 $X=65625 $Y=-197150 $D=37
M46 33 20 36 GNDA nmos4 L=1e-05 W=2e-06 AD=1.7e-12 AS=1.7e-12 PD=3.7e-06 PS=3.7e-06 NRD=0.2125 NRS=0.2125 $X=65625 $Y=-165550 $D=37
M47 34 20 GNDA GNDA nmos4 L=1e-05 W=2e-06 AD=1.7e-12 AS=1.7e-12 PD=3.7e-06 PS=3.7e-06 NRD=0.2125 NRS=0.2125 $X=68875 $Y=-212950 $D=37
M48 35 20 GNDA GNDA nmos4 L=1e-05 W=2e-06 AD=1.7e-12 AS=1.7e-12 PD=3.7e-06 PS=3.7e-06 NRD=0.2125 NRS=0.2125 $X=68875 $Y=-197150 $D=37
M49 36 20 GNDA GNDA nmos4 L=1e-05 W=2e-06 AD=1.7e-12 AS=1.7e-12 PD=3.7e-06 PS=3.7e-06 NRD=0.2125 NRS=0.2125 $X=68875 $Y=-165550 $D=37
M50 34 20 GNDA GNDA nmos4 L=1e-05 W=2e-06 AD=1.7e-12 AS=1.7e-12 PD=3.7e-06 PS=3.7e-06 NRD=0.2125 NRS=0.2125 $X=72125 $Y=-212950 $D=37
M51 35 20 GNDA GNDA nmos4 L=1e-05 W=2e-06 AD=1.7e-12 AS=1.7e-12 PD=3.7e-06 PS=3.7e-06 NRD=0.2125 NRS=0.2125 $X=72125 $Y=-197150 $D=37
M52 36 20 GNDA GNDA nmos4 L=1e-05 W=2e-06 AD=1.7e-12 AS=1.7e-12 PD=3.7e-06 PS=3.7e-06 NRD=0.2125 NRS=0.2125 $X=72125 $Y=-165550 $D=37
M53 34 20 GNDA GNDA nmos4 L=1e-05 W=2e-06 AD=1.7e-12 AS=1.7e-12 PD=3.7e-06 PS=3.7e-06 NRD=0.2125 NRS=0.2125 $X=75375 $Y=-212950 $D=37
M54 35 20 GNDA GNDA nmos4 L=1e-05 W=2e-06 AD=1.7e-12 AS=1.7e-12 PD=3.7e-06 PS=3.7e-06 NRD=0.2125 NRS=0.2125 $X=75375 $Y=-197150 $D=37
M55 36 20 GNDA GNDA nmos4 L=1e-05 W=2e-06 AD=1.7e-12 AS=1.7e-12 PD=3.7e-06 PS=3.7e-06 NRD=0.2125 NRS=0.2125 $X=75375 $Y=-165550 $D=37
M56 37 4 GNDA GNDA nmos4 L=2e-05 W=2e-06 AD=1.7e-12 AS=1.7e-12 PD=3.7e-06 PS=3.7e-06 NRD=0.2125 NRS=0.2125 $X=115250 $Y=-232600 $D=37
M57 38 4 37 GNDA nmos4 L=2e-05 W=2e-06 AD=1.7e-12 AS=1.7e-12 PD=3.7e-06 PS=3.7e-06 NRD=0.2125 NRS=0.2125 $X=115250 $Y=-206800 $D=37
M58 39 4 38 GNDA nmos4 L=2e-05 W=2e-06 AD=1.7e-12 AS=1.7e-12 PD=3.7e-06 PS=3.7e-06 NRD=0.2125 NRS=0.2125 $X=115250 $Y=-181000 $D=37
M59 1 4 39 GNDA nmos4 L=2e-05 W=2e-06 AD=1.7e-12 AS=1.7e-12 PD=3.7e-06 PS=3.7e-06 NRD=0.2125 NRS=0.2125 $X=115250 $Y=-155200 $D=37
M60 40 4 GNDA GNDA nmos4 L=2e-05 W=2e-06 AD=1.7e-12 AS=1.7e-12 PD=3.7e-06 PS=3.7e-06 NRD=0.2125 NRS=0.2125 $X=118500 $Y=-232600 $D=37
M61 41 4 40 GNDA nmos4 L=2e-05 W=2e-06 AD=1.7e-12 AS=1.7e-12 PD=3.7e-06 PS=3.7e-06 NRD=0.2125 NRS=0.2125 $X=118500 $Y=-206800 $D=37
M62 42 4 41 GNDA nmos4 L=2e-05 W=2e-06 AD=1.7e-12 AS=1.7e-12 PD=3.7e-06 PS=3.7e-06 NRD=0.2125 NRS=0.2125 $X=118500 $Y=-181000 $D=37
M63 1 4 42 GNDA nmos4 L=2e-05 W=2e-06 AD=1.7e-12 AS=1.7e-12 PD=3.7e-06 PS=3.7e-06 NRD=0.2125 NRS=0.2125 $X=118500 $Y=-155200 $D=37
M64 43 4 GNDA GNDA nmos4 L=2e-05 W=2e-06 AD=1.7e-12 AS=1.7e-12 PD=3.7e-06 PS=3.7e-06 NRD=0.2125 NRS=0.2125 $X=121750 $Y=-232600 $D=37
M65 44 4 43 GNDA nmos4 L=2e-05 W=2e-06 AD=1.7e-12 AS=1.7e-12 PD=3.7e-06 PS=3.7e-06 NRD=0.2125 NRS=0.2125 $X=121750 $Y=-206800 $D=37
M66 45 4 44 GNDA nmos4 L=2e-05 W=2e-06 AD=1.7e-12 AS=1.7e-12 PD=3.7e-06 PS=3.7e-06 NRD=0.2125 NRS=0.2125 $X=121750 $Y=-181000 $D=37
M67 1 4 45 GNDA nmos4 L=2e-05 W=2e-06 AD=1.7e-12 AS=1.7e-12 PD=3.7e-06 PS=3.7e-06 NRD=0.2125 NRS=0.2125 $X=121750 $Y=-155200 $D=37
M68 46 4 GNDA GNDA nmos4 L=2e-05 W=2e-06 AD=1.7e-12 AS=1.7e-12 PD=3.7e-06 PS=3.7e-06 NRD=0.2125 NRS=0.2125 $X=125000 $Y=-232600 $D=37
M69 47 4 46 GNDA nmos4 L=2e-05 W=2e-06 AD=1.7e-12 AS=1.7e-12 PD=3.7e-06 PS=3.7e-06 NRD=0.2125 NRS=0.2125 $X=125000 $Y=-206800 $D=37
M70 48 4 47 GNDA nmos4 L=2e-05 W=2e-06 AD=1.7e-12 AS=1.7e-12 PD=3.7e-06 PS=3.7e-06 NRD=0.2125 NRS=0.2125 $X=125000 $Y=-181000 $D=37
M71 1 4 48 GNDA nmos4 L=2e-05 W=2e-06 AD=1.7e-12 AS=1.7e-12 PD=3.7e-06 PS=3.7e-06 NRD=0.2125 NRS=0.2125 $X=125000 $Y=-155200 $D=37
M72 49 4 GNDA GNDA nmos4 L=2e-05 W=2e-06 AD=1.7e-12 AS=1.7e-12 PD=3.7e-06 PS=3.7e-06 NRD=0.2125 NRS=0.2125 $X=128250 $Y=-232600 $D=37
M73 50 4 49 GNDA nmos4 L=2e-05 W=2e-06 AD=1.7e-12 AS=1.7e-12 PD=3.7e-06 PS=3.7e-06 NRD=0.2125 NRS=0.2125 $X=128250 $Y=-206800 $D=37
M74 51 4 50 GNDA nmos4 L=2e-05 W=2e-06 AD=1.7e-12 AS=1.7e-12 PD=3.7e-06 PS=3.7e-06 NRD=0.2125 NRS=0.2125 $X=128250 $Y=-181000 $D=37
M75 1 4 51 GNDA nmos4 L=2e-05 W=2e-06 AD=1.7e-12 AS=1.7e-12 PD=3.7e-06 PS=3.7e-06 NRD=0.2125 NRS=0.2125 $X=128250 $Y=-155200 $D=37
M76 52 4 GNDA GNDA nmos4 L=2e-05 W=2e-06 AD=1.7e-12 AS=1.7e-12 PD=3.7e-06 PS=3.7e-06 NRD=0.2125 NRS=0.2125 $X=131500 $Y=-232600 $D=37
M77 53 4 52 GNDA nmos4 L=2e-05 W=2e-06 AD=1.7e-12 AS=1.7e-12 PD=3.7e-06 PS=3.7e-06 NRD=0.2125 NRS=0.2125 $X=131500 $Y=-206800 $D=37
M78 54 4 53 GNDA nmos4 L=2e-05 W=2e-06 AD=1.7e-12 AS=1.7e-12 PD=3.7e-06 PS=3.7e-06 NRD=0.2125 NRS=0.2125 $X=131500 $Y=-181000 $D=37
M79 1 4 54 GNDA nmos4 L=2e-05 W=2e-06 AD=1.7e-12 AS=1.7e-12 PD=3.7e-06 PS=3.7e-06 NRD=0.2125 NRS=0.2125 $X=131500 $Y=-155200 $D=37
M80 86 4 GNDA GNDA nmos4 L=2e-05 W=2e-06 AD=1.7e-12 AS=1.7e-12 PD=3.7e-06 PS=3.7e-06 NRD=0.2125 NRS=0.2125 $X=160750 $Y=-232600 $D=37
M81 87 4 86 GNDA nmos4 L=2e-05 W=2e-06 AD=1.7e-12 AS=1.7e-12 PD=3.7e-06 PS=3.7e-06 NRD=0.2125 NRS=0.2125 $X=160750 $Y=-206800 $D=37
M82 88 4 87 GNDA nmos4 L=2e-05 W=2e-06 AD=1.7e-12 AS=1.7e-12 PD=3.7e-06 PS=3.7e-06 NRD=0.2125 NRS=0.2125 $X=160750 $Y=-181000 $D=37
M83 1 4 88 GNDA nmos4 L=2e-05 W=2e-06 AD=1.7e-12 AS=1.7e-12 PD=3.7e-06 PS=3.7e-06 NRD=0.2125 NRS=0.2125 $X=160750 $Y=-155200 $D=37
M84 89 4 GNDA GNDA nmos4 L=2e-05 W=2e-06 AD=1.7e-12 AS=1.7e-12 PD=3.7e-06 PS=3.7e-06 NRD=0.2125 NRS=0.2125 $X=164000 $Y=-232600 $D=37
M85 90 4 89 GNDA nmos4 L=2e-05 W=2e-06 AD=1.7e-12 AS=1.7e-12 PD=3.7e-06 PS=3.7e-06 NRD=0.2125 NRS=0.2125 $X=164000 $Y=-206800 $D=37
M86 91 4 90 GNDA nmos4 L=2e-05 W=2e-06 AD=1.7e-12 AS=1.7e-12 PD=3.7e-06 PS=3.7e-06 NRD=0.2125 NRS=0.2125 $X=164000 $Y=-181000 $D=37
M87 1 4 91 GNDA nmos4 L=2e-05 W=2e-06 AD=1.7e-12 AS=1.7e-12 PD=3.7e-06 PS=3.7e-06 NRD=0.2125 NRS=0.2125 $X=164000 $Y=-155200 $D=37
M88 92 4 GNDA GNDA nmos4 L=2e-05 W=2e-06 AD=1.7e-12 AS=1.7e-12 PD=3.7e-06 PS=3.7e-06 NRD=0.2125 NRS=0.2125 $X=167250 $Y=-232600 $D=37
M89 93 4 92 GNDA nmos4 L=2e-05 W=2e-06 AD=1.7e-12 AS=1.7e-12 PD=3.7e-06 PS=3.7e-06 NRD=0.2125 NRS=0.2125 $X=167250 $Y=-206800 $D=37
M90 94 4 93 GNDA nmos4 L=2e-05 W=2e-06 AD=1.7e-12 AS=1.7e-12 PD=3.7e-06 PS=3.7e-06 NRD=0.2125 NRS=0.2125 $X=167250 $Y=-181000 $D=37
M91 1 4 94 GNDA nmos4 L=2e-05 W=2e-06 AD=1.7e-12 AS=1.7e-12 PD=3.7e-06 PS=3.7e-06 NRD=0.2125 NRS=0.2125 $X=167250 $Y=-155200 $D=37
M92 95 4 GNDA GNDA nmos4 L=2e-05 W=2e-06 AD=1.7e-12 AS=1.7e-12 PD=3.7e-06 PS=3.7e-06 NRD=0.2125 NRS=0.2125 $X=170500 $Y=-232600 $D=37
M93 96 4 95 GNDA nmos4 L=2e-05 W=2e-06 AD=1.7e-12 AS=1.7e-12 PD=3.7e-06 PS=3.7e-06 NRD=0.2125 NRS=0.2125 $X=170500 $Y=-206800 $D=37
M94 97 4 96 GNDA nmos4 L=2e-05 W=2e-06 AD=1.7e-12 AS=1.7e-12 PD=3.7e-06 PS=3.7e-06 NRD=0.2125 NRS=0.2125 $X=170500 $Y=-181000 $D=37
M95 1 4 97 GNDA nmos4 L=2e-05 W=2e-06 AD=1.7e-12 AS=1.7e-12 PD=3.7e-06 PS=3.7e-06 NRD=0.2125 NRS=0.2125 $X=170500 $Y=-155200 $D=37
M96 98 4 GNDA GNDA nmos4 L=2e-05 W=2e-06 AD=1.7e-12 AS=1.7e-12 PD=3.7e-06 PS=3.7e-06 NRD=0.2125 NRS=0.2125 $X=173750 $Y=-232600 $D=37
M97 99 4 98 GNDA nmos4 L=2e-05 W=2e-06 AD=1.7e-12 AS=1.7e-12 PD=3.7e-06 PS=3.7e-06 NRD=0.2125 NRS=0.2125 $X=173750 $Y=-206800 $D=37
M98 100 4 99 GNDA nmos4 L=2e-05 W=2e-06 AD=1.7e-12 AS=1.7e-12 PD=3.7e-06 PS=3.7e-06 NRD=0.2125 NRS=0.2125 $X=173750 $Y=-181000 $D=37
M99 1 4 100 GNDA nmos4 L=2e-05 W=2e-06 AD=1.7e-12 AS=1.7e-12 PD=3.7e-06 PS=3.7e-06 NRD=0.2125 NRS=0.2125 $X=173750 $Y=-155200 $D=37
M100 101 4 GNDA GNDA nmos4 L=2e-05 W=2e-06 AD=1.7e-12 AS=1.7e-12 PD=3.7e-06 PS=3.7e-06 NRD=0.2125 NRS=0.2125 $X=177000 $Y=-232600 $D=37
M101 102 4 101 GNDA nmos4 L=2e-05 W=2e-06 AD=1.7e-12 AS=1.7e-12 PD=3.7e-06 PS=3.7e-06 NRD=0.2125 NRS=0.2125 $X=177000 $Y=-206800 $D=37
M102 103 4 102 GNDA nmos4 L=2e-05 W=2e-06 AD=1.7e-12 AS=1.7e-12 PD=3.7e-06 PS=3.7e-06 NRD=0.2125 NRS=0.2125 $X=177000 $Y=-181000 $D=37
M103 1 4 103 GNDA nmos4 L=2e-05 W=2e-06 AD=1.7e-12 AS=1.7e-12 PD=3.7e-06 PS=3.7e-06 NRD=0.2125 NRS=0.2125 $X=177000 $Y=-155200 $D=37
M104 104 5 GNDA GNDA nmos4 L=2e-05 W=2e-06 AD=1.7e-12 AS=1.7e-12 PD=3.7e-06 PS=3.7e-06 NRD=0.2125 NRS=0.2125 $X=204025 $Y=-232600 $D=37
M105 105 5 104 GNDA nmos4 L=2e-05 W=2e-06 AD=1.7e-12 AS=1.7e-12 PD=3.7e-06 PS=3.7e-06 NRD=0.2125 NRS=0.2125 $X=204025 $Y=-206800 $D=37
M106 106 5 105 GNDA nmos4 L=2e-05 W=2e-06 AD=1.7e-12 AS=1.7e-12 PD=3.7e-06 PS=3.7e-06 NRD=0.2125 NRS=0.2125 $X=204025 $Y=-181000 $D=37
M107 2 5 106 GNDA nmos4 L=2e-05 W=2e-06 AD=1.7e-12 AS=1.7e-12 PD=3.7e-06 PS=3.7e-06 NRD=0.2125 NRS=0.2125 $X=204025 $Y=-155200 $D=37
M108 107 5 GNDA GNDA nmos4 L=2e-05 W=2e-06 AD=1.7e-12 AS=1.7e-12 PD=3.7e-06 PS=3.7e-06 NRD=0.2125 NRS=0.2125 $X=207275 $Y=-232600 $D=37
M109 108 5 107 GNDA nmos4 L=2e-05 W=2e-06 AD=1.7e-12 AS=1.7e-12 PD=3.7e-06 PS=3.7e-06 NRD=0.2125 NRS=0.2125 $X=207275 $Y=-206800 $D=37
M110 109 5 108 GNDA nmos4 L=2e-05 W=2e-06 AD=1.7e-12 AS=1.7e-12 PD=3.7e-06 PS=3.7e-06 NRD=0.2125 NRS=0.2125 $X=207275 $Y=-181000 $D=37
M111 2 5 109 GNDA nmos4 L=2e-05 W=2e-06 AD=1.7e-12 AS=1.7e-12 PD=3.7e-06 PS=3.7e-06 NRD=0.2125 NRS=0.2125 $X=207275 $Y=-155200 $D=37
M112 110 5 GNDA GNDA nmos4 L=2e-05 W=2e-06 AD=1.7e-12 AS=1.7e-12 PD=3.7e-06 PS=3.7e-06 NRD=0.2125 NRS=0.2125 $X=210525 $Y=-232600 $D=37
M113 111 5 110 GNDA nmos4 L=2e-05 W=2e-06 AD=1.7e-12 AS=1.7e-12 PD=3.7e-06 PS=3.7e-06 NRD=0.2125 NRS=0.2125 $X=210525 $Y=-206800 $D=37
M114 112 5 111 GNDA nmos4 L=2e-05 W=2e-06 AD=1.7e-12 AS=1.7e-12 PD=3.7e-06 PS=3.7e-06 NRD=0.2125 NRS=0.2125 $X=210525 $Y=-181000 $D=37
M115 2 5 112 GNDA nmos4 L=2e-05 W=2e-06 AD=1.7e-12 AS=1.7e-12 PD=3.7e-06 PS=3.7e-06 NRD=0.2125 NRS=0.2125 $X=210525 $Y=-155200 $D=37
M116 113 5 GNDA GNDA nmos4 L=2e-05 W=2e-06 AD=1.7e-12 AS=1.7e-12 PD=3.7e-06 PS=3.7e-06 NRD=0.2125 NRS=0.2125 $X=213775 $Y=-232600 $D=37
M117 114 5 113 GNDA nmos4 L=2e-05 W=2e-06 AD=1.7e-12 AS=1.7e-12 PD=3.7e-06 PS=3.7e-06 NRD=0.2125 NRS=0.2125 $X=213775 $Y=-206800 $D=37
M118 115 5 114 GNDA nmos4 L=2e-05 W=2e-06 AD=1.7e-12 AS=1.7e-12 PD=3.7e-06 PS=3.7e-06 NRD=0.2125 NRS=0.2125 $X=213775 $Y=-181000 $D=37
M119 2 5 115 GNDA nmos4 L=2e-05 W=2e-06 AD=1.7e-12 AS=1.7e-12 PD=3.7e-06 PS=3.7e-06 NRD=0.2125 NRS=0.2125 $X=213775 $Y=-155200 $D=37
M120 116 5 GNDA GNDA nmos4 L=2e-05 W=2e-06 AD=1.7e-12 AS=1.7e-12 PD=3.7e-06 PS=3.7e-06 NRD=0.2125 NRS=0.2125 $X=217025 $Y=-232600 $D=37
M121 117 5 116 GNDA nmos4 L=2e-05 W=2e-06 AD=1.7e-12 AS=1.7e-12 PD=3.7e-06 PS=3.7e-06 NRD=0.2125 NRS=0.2125 $X=217025 $Y=-206800 $D=37
M122 118 5 117 GNDA nmos4 L=2e-05 W=2e-06 AD=1.7e-12 AS=1.7e-12 PD=3.7e-06 PS=3.7e-06 NRD=0.2125 NRS=0.2125 $X=217025 $Y=-181000 $D=37
M123 2 5 118 GNDA nmos4 L=2e-05 W=2e-06 AD=1.7e-12 AS=1.7e-12 PD=3.7e-06 PS=3.7e-06 NRD=0.2125 NRS=0.2125 $X=217025 $Y=-155200 $D=37
M124 119 5 GNDA GNDA nmos4 L=2e-05 W=2e-06 AD=1.7e-12 AS=1.7e-12 PD=3.7e-06 PS=3.7e-06 NRD=0.2125 NRS=0.2125 $X=220275 $Y=-232600 $D=37
M125 120 5 119 GNDA nmos4 L=2e-05 W=2e-06 AD=1.7e-12 AS=1.7e-12 PD=3.7e-06 PS=3.7e-06 NRD=0.2125 NRS=0.2125 $X=220275 $Y=-206800 $D=37
M126 121 5 120 GNDA nmos4 L=2e-05 W=2e-06 AD=1.7e-12 AS=1.7e-12 PD=3.7e-06 PS=3.7e-06 NRD=0.2125 NRS=0.2125 $X=220275 $Y=-181000 $D=37
M127 2 5 121 GNDA nmos4 L=2e-05 W=2e-06 AD=1.7e-12 AS=1.7e-12 PD=3.7e-06 PS=3.7e-06 NRD=0.2125 NRS=0.2125 $X=220275 $Y=-155200 $D=37
M128 153 5 GNDA GNDA nmos4 L=2e-05 W=2e-06 AD=1.7e-12 AS=1.7e-12 PD=3.7e-06 PS=3.7e-06 NRD=0.2125 NRS=0.2125 $X=249525 $Y=-232600 $D=37
M129 154 5 153 GNDA nmos4 L=2e-05 W=2e-06 AD=1.7e-12 AS=1.7e-12 PD=3.7e-06 PS=3.7e-06 NRD=0.2125 NRS=0.2125 $X=249525 $Y=-206800 $D=37
M130 155 5 154 GNDA nmos4 L=2e-05 W=2e-06 AD=1.7e-12 AS=1.7e-12 PD=3.7e-06 PS=3.7e-06 NRD=0.2125 NRS=0.2125 $X=249525 $Y=-181000 $D=37
M131 2 5 155 GNDA nmos4 L=2e-05 W=2e-06 AD=1.7e-12 AS=1.7e-12 PD=3.7e-06 PS=3.7e-06 NRD=0.2125 NRS=0.2125 $X=249525 $Y=-155200 $D=37
M132 156 5 GNDA GNDA nmos4 L=2e-05 W=2e-06 AD=1.7e-12 AS=1.7e-12 PD=3.7e-06 PS=3.7e-06 NRD=0.2125 NRS=0.2125 $X=252775 $Y=-232600 $D=37
M133 157 5 156 GNDA nmos4 L=2e-05 W=2e-06 AD=1.7e-12 AS=1.7e-12 PD=3.7e-06 PS=3.7e-06 NRD=0.2125 NRS=0.2125 $X=252775 $Y=-206800 $D=37
M134 158 5 157 GNDA nmos4 L=2e-05 W=2e-06 AD=1.7e-12 AS=1.7e-12 PD=3.7e-06 PS=3.7e-06 NRD=0.2125 NRS=0.2125 $X=252775 $Y=-181000 $D=37
M135 2 5 158 GNDA nmos4 L=2e-05 W=2e-06 AD=1.7e-12 AS=1.7e-12 PD=3.7e-06 PS=3.7e-06 NRD=0.2125 NRS=0.2125 $X=252775 $Y=-155200 $D=37
M136 159 5 GNDA GNDA nmos4 L=2e-05 W=2e-06 AD=1.7e-12 AS=1.7e-12 PD=3.7e-06 PS=3.7e-06 NRD=0.2125 NRS=0.2125 $X=256025 $Y=-232600 $D=37
M137 160 5 159 GNDA nmos4 L=2e-05 W=2e-06 AD=1.7e-12 AS=1.7e-12 PD=3.7e-06 PS=3.7e-06 NRD=0.2125 NRS=0.2125 $X=256025 $Y=-206800 $D=37
M138 161 5 160 GNDA nmos4 L=2e-05 W=2e-06 AD=1.7e-12 AS=1.7e-12 PD=3.7e-06 PS=3.7e-06 NRD=0.2125 NRS=0.2125 $X=256025 $Y=-181000 $D=37
M139 2 5 161 GNDA nmos4 L=2e-05 W=2e-06 AD=1.7e-12 AS=1.7e-12 PD=3.7e-06 PS=3.7e-06 NRD=0.2125 NRS=0.2125 $X=256025 $Y=-155200 $D=37
M140 162 5 GNDA GNDA nmos4 L=2e-05 W=2e-06 AD=1.7e-12 AS=1.7e-12 PD=3.7e-06 PS=3.7e-06 NRD=0.2125 NRS=0.2125 $X=259275 $Y=-232600 $D=37
M141 163 5 162 GNDA nmos4 L=2e-05 W=2e-06 AD=1.7e-12 AS=1.7e-12 PD=3.7e-06 PS=3.7e-06 NRD=0.2125 NRS=0.2125 $X=259275 $Y=-206800 $D=37
M142 164 5 163 GNDA nmos4 L=2e-05 W=2e-06 AD=1.7e-12 AS=1.7e-12 PD=3.7e-06 PS=3.7e-06 NRD=0.2125 NRS=0.2125 $X=259275 $Y=-181000 $D=37
M143 2 5 164 GNDA nmos4 L=2e-05 W=2e-06 AD=1.7e-12 AS=1.7e-12 PD=3.7e-06 PS=3.7e-06 NRD=0.2125 NRS=0.2125 $X=259275 $Y=-155200 $D=37
M144 165 5 GNDA GNDA nmos4 L=2e-05 W=2e-06 AD=1.7e-12 AS=1.7e-12 PD=3.7e-06 PS=3.7e-06 NRD=0.2125 NRS=0.2125 $X=262525 $Y=-232600 $D=37
M145 166 5 165 GNDA nmos4 L=2e-05 W=2e-06 AD=1.7e-12 AS=1.7e-12 PD=3.7e-06 PS=3.7e-06 NRD=0.2125 NRS=0.2125 $X=262525 $Y=-206800 $D=37
M146 167 5 166 GNDA nmos4 L=2e-05 W=2e-06 AD=1.7e-12 AS=1.7e-12 PD=3.7e-06 PS=3.7e-06 NRD=0.2125 NRS=0.2125 $X=262525 $Y=-181000 $D=37
M147 2 5 167 GNDA nmos4 L=2e-05 W=2e-06 AD=1.7e-12 AS=1.7e-12 PD=3.7e-06 PS=3.7e-06 NRD=0.2125 NRS=0.2125 $X=262525 $Y=-155200 $D=37
M148 168 5 GNDA GNDA nmos4 L=2e-05 W=2e-06 AD=1.7e-12 AS=1.7e-12 PD=3.7e-06 PS=3.7e-06 NRD=0.2125 NRS=0.2125 $X=265775 $Y=-232600 $D=37
M149 169 5 168 GNDA nmos4 L=2e-05 W=2e-06 AD=1.7e-12 AS=1.7e-12 PD=3.7e-06 PS=3.7e-06 NRD=0.2125 NRS=0.2125 $X=265775 $Y=-206800 $D=37
M150 170 5 169 GNDA nmos4 L=2e-05 W=2e-06 AD=1.7e-12 AS=1.7e-12 PD=3.7e-06 PS=3.7e-06 NRD=0.2125 NRS=0.2125 $X=265775 $Y=-181000 $D=37
M151 2 5 170 GNDA nmos4 L=2e-05 W=2e-06 AD=1.7e-12 AS=1.7e-12 PD=3.7e-06 PS=3.7e-06 NRD=0.2125 NRS=0.2125 $X=265775 $Y=-155200 $D=37
M152 VDDA VDDA VDDA VDDA pmos4 L=5e-06 W=6e-06 AD=5.1e-12 AS=5.1e-12 PD=7.7e-06 PS=7.7e-06 NRD=0.0708333 NRS=0.0708333 $X=50075 $Y=-83200 $D=42
M153 VDDA VDDA VDDA VDDA pmos4 L=5e-06 W=6e-06 AD=5.1e-12 AS=5.1e-12 PD=7.7e-06 PS=7.7e-06 NRD=0.0708333 NRS=0.0708333 $X=50075 $Y=-70800 $D=42
M154 VDDA VDDA VDDA VDDA pmos4 L=5e-06 W=6e-06 AD=5.1e-12 AS=5.1e-12 PD=7.7e-06 PS=7.7e-06 NRD=0.0708333 NRS=0.0708333 $X=137675 $Y=-83200 $D=42
M155 VDDA VDDA VDDA VDDA pmos4 L=5e-06 W=6e-06 AD=5.1e-12 AS=5.1e-12 PD=7.7e-06 PS=7.7e-06 NRD=0.0708333 NRS=0.0708333 $X=137675 $Y=-70800 $D=42
M156 2 18 VDDA VDDA pmos4 L=5e-06 W=6e-06 AD=5.1e-12 AS=5.1e-12 PD=7.7e-06 PS=7.7e-06 NRD=0.0708333 NRS=0.0708333 $X=79275 $Y=-83200 $D=41
M157 1 18 VDDA VDDA pmos4 L=5e-06 W=6e-06 AD=5.1e-12 AS=5.1e-12 PD=7.7e-06 PS=7.7e-06 NRD=0.0708333 NRS=0.0708333 $X=79275 $Y=-70800 $D=41
M158 1 18 VDDA VDDA pmos4 L=5e-06 W=6e-06 AD=5.1e-12 AS=5.1e-12 PD=7.7e-06 PS=7.7e-06 NRD=0.0708333 NRS=0.0708333 $X=108475 $Y=-83200 $D=41
M159 2 18 VDDA VDDA pmos4 L=5e-06 W=6e-06 AD=5.1e-12 AS=5.1e-12 PD=7.7e-06 PS=7.7e-06 NRD=0.0708333 NRS=0.0708333 $X=108475 $Y=-70800 $D=41
M160 OUT 7 23 VDDA pmos4 L=5e-06 W=5e-06 AD=4.25e-12 AS=4.25e-12 PD=6.7e-06 PS=6.7e-06 NRD=0.085 NRS=0.085 $X=291675 $Y=-69800 $D=41
M161 7 7 22 VDDA pmos4 L=5e-06 W=5e-06 AD=4.25e-12 AS=4.25e-12 PD=6.7e-06 PS=6.7e-06 NRD=0.085 NRS=0.085 $X=298975 $Y=-69800 $D=41
M162 22 7 VDDA VDDA pmos4 L=5e-06 W=5e-06 AD=4.25e-12 AS=4.25e-12 PD=6.7e-06 PS=6.7e-06 NRD=0.085 NRS=0.085 $X=306275 $Y=-69800 $D=41
M163 23 7 VDDA VDDA pmos4 L=5e-06 W=5e-06 AD=4.25e-12 AS=4.25e-12 PD=6.7e-06 PS=6.7e-06 NRD=0.085 NRS=0.085 $X=313575 $Y=-69800 $D=41
C164 GNDA VDDA $[cpolya] $A=1494 $P=169.8 $X=388100 $Y=-55550 $D=58
X165 21 18 BIAS GNDA nmos4_CDNS_7807366010340 $T=44425 -116900 0 270 $X=44175 $Y=-127450
X166 20 BIAS BIAS GNDA nmos4_CDNS_7807366010340 $T=56225 -116900 0 270 $X=55975 $Y=-127450
X175 GNDA ICV_68 $T=75375 -223600 0 0 $X=74975 $Y=-223850
X176 GNDA ICV_68 $T=75375 -150600 0 0 $X=74975 $Y=-150850
X177 GNDA ICV_70 $T=36375 -223600 0 0 $X=35975 $Y=-223850
X178 GNDA ICV_70 $T=36375 -150600 0 0 $X=35975 $Y=-150850
X179 GNDA ICV_70 $T=49375 -223600 0 0 $X=48975 $Y=-223850
X180 GNDA ICV_70 $T=49375 -150600 0 0 $X=48975 $Y=-150850
X181 GNDA ICV_70 $T=62375 -223600 0 0 $X=61975 $Y=-223850
X182 GNDA ICV_70 $T=62375 -150600 0 0 $X=61975 $Y=-150850
X191 20 26 5 26 5 30 26 30 26 34 30 GNDA ICV_72 $T=36375 -213800 0 0 $X=35975 $Y=-214050
X192 20 27 4 27 4 31 27 31 27 35 31 GNDA ICV_72 $T=36375 -198000 0 0 $X=35975 $Y=-198250
X193 20 GNDA 25 25 29 25 29 29 32 32 20 GNDA ICV_72 $T=36375 -182200 0 0 $X=35975 $Y=-182450
X194 20 28 21 28 21 33 28 33 28 36 33 GNDA ICV_72 $T=36375 -166400 0 0 $X=35975 $Y=-166650
X195 GNDA BIAS cpolyc_CDNS_78073660103100 $T=93650 -271900 0 90 $X=60300 $Y=-273250
X198 VDDA 1 2 1 18 ICV_67 $T=49225 -77200 0 270 $X=48025 $Y=-84400
X199 VDDA 2 1 2 18 ICV_67 $T=49225 -64800 0 270 $X=48025 $Y=-72000
X200 VDDA 1 18 2 18 ICV_67 $T=78425 -77200 0 270 $X=77225 $Y=-84400
X201 VDDA 2 18 1 18 ICV_67 $T=78425 -64800 0 270 $X=77225 $Y=-72000
X202 VDDA 2 1 2 18 ICV_67 $T=107625 -77200 0 270 $X=106425 $Y=-84400
X203 VDDA 1 2 1 18 ICV_67 $T=107625 -64800 0 270 $X=106425 $Y=-72000
X204 1 4 INN pmos4_CDNS_78073660103103 $T=194925 -101100 1 90 $X=193725 $Y=-102300
X205 2 5 INP pmos4_CDNS_78073660103103 $T=194925 -62000 0 270 $X=193725 $Y=-78200
X206 2 5 INP pmos4_CDNS_78073660103103 $T=234025 -101100 1 90 $X=232825 $Y=-102300
X207 1 4 INN pmos4_CDNS_78073660103103 $T=234025 -62000 0 270 $X=232825 $Y=-78200
X212 S<0> VDDA GNDA 19 INVX1 $T=334400 -65900 0 0 $X=333550 $Y=-67250
X213 S<1> VDDA GNDA 24 INVX1 $T=339900 -65900 0 0 $X=339050 $Y=-67250
X214 S<2> VDDA GNDA 171 INVX1 $T=345550 -65900 0 0 $X=344700 $Y=-67250
X215 OUT 10 171 VDDA pmos4_CDNS_7807366010394 $T=357000 -57650 1 90 $X=355800 $Y=-58850
X216 OUT 11 24 VDDA pmos4_CDNS_7807366010394 $T=367250 -57650 1 90 $X=366050 $Y=-58850
X217 OUT 12 19 VDDA pmos4_CDNS_7807366010394 $T=376950 -57650 1 90 $X=375750 $Y=-58850
X218 10 OUT S<2> GNDA nmos4_CDNS_7807366010397 $T=359700 -66150 0 90 $X=356750 $Y=-66550
X219 11 OUT S<1> GNDA nmos4_CDNS_7807366010397 $T=369950 -66150 0 90 $X=367000 $Y=-66550
X220 12 OUT S<0> GNDA nmos4_CDNS_7807366010397 $T=379650 -66150 0 90 $X=376700 $Y=-66550
X254 4 GNDA 58 58 62 62 66 66 70 70 74 74 78 78 82 82 7 GNDA ICV_65 $T=112000 -260050 0 0 $X=111600 $Y=-260300
X255 4 GNDA 55 GNDA 59 GNDA 63 GNDA 67 GNDA 71 GNDA 75 GNDA 79 GNDA 83 GNDA ICV_65 $T=112000 -233450 0 0 $X=111600 $Y=-233700
X256 4 55 56 59 60 63 64 67 68 71 72 75 76 79 80 83 84 GNDA ICV_65 $T=112000 -207650 0 0 $X=111600 $Y=-207900
X257 4 56 57 60 61 64 65 68 69 72 73 76 77 80 81 84 85 GNDA ICV_65 $T=112000 -181850 0 0 $X=111600 $Y=-182100
X258 4 57 1 61 1 65 1 69 1 73 1 77 1 81 1 85 1 GNDA ICV_65 $T=112000 -156050 0 0 $X=111600 $Y=-156300
X259 5 GNDA 125 125 129 129 133 133 137 137 141 141 145 145 149 149 OUT GNDA ICV_65 $T=200775 -259250 0 0 $X=200375 $Y=-259500
X260 5 GNDA 122 GNDA 126 GNDA 130 GNDA 134 GNDA 138 GNDA 142 GNDA 146 GNDA 150 GNDA ICV_65 $T=200775 -233450 0 0 $X=200375 $Y=-233700
X261 5 122 123 126 127 130 131 134 135 138 139 142 143 146 147 150 151 GNDA ICV_65 $T=200775 -207650 0 0 $X=200375 $Y=-207900
X262 5 123 124 127 128 131 132 135 136 139 140 143 144 147 148 151 152 GNDA ICV_65 $T=200775 -181850 0 0 $X=200375 $Y=-182100
X263 5 124 2 128 2 132 2 136 2 140 2 144 2 148 2 152 2 GNDA ICV_65 $T=200775 -156050 0 0 $X=200375 $Y=-156300
X275 GNDA OUT cpolyc_CDNS_78073660103149 $T=346000 -261750 0 0 $X=344650 $Y=-263100
X276 GNDA OUT cpolyc_CDNS_78073660103149 $T=460600 -148450 0 0 $X=459250 $Y=-149800
X277 GNDA OUT cpolyc_CDNS_78073660103149 $T=460650 -261750 0 0 $X=459300 $Y=-263100
X278 GNDA 11 cpolyc_CDNS_78073660103148 $T=577950 -261750 0 0 $X=576600 $Y=-263100
X279 GNDA 11 cpolyc_CDNS_78073660103148 $T=577950 -197550 0 0 $X=576600 $Y=-198900
X280 GNDA 11 cpolyc_CDNS_78073660103148 $T=643700 -261750 0 0 $X=642350 $Y=-263100
X281 GNDA 11 cpolyc_CDNS_78073660103148 $T=643700 -197550 0 0 $X=642350 $Y=-198900
X282 GNDA 11 cpolyc_CDNS_78073660103148 $T=709450 -261750 0 0 $X=708100 $Y=-263100
X283 GNDA 11 cpolyc_CDNS_78073660103148 $T=709450 -197550 0 0 $X=708100 $Y=-198900
X284 GNDA 12 cpolyc_CDNS_78073660103147 $T=577950 -39250 0 270 $X=576600 $Y=-109200
X285 GNDA 12 cpolyc_CDNS_78073660103147 $T=649050 -39250 0 270 $X=647700 $Y=-109200
X286 GNDA 12 cpolyc_CDNS_78073660103147 $T=720200 -39250 0 270 $X=718850 $Y=-109200
X287 GNDA 10 cpolyc_CDNS_78073660103145 $T=950600 -261750 0 0 $X=949250 $Y=-263100
X288 GNDA 10 cpolyc_CDNS_78073660103145 $T=950600 -206050 0 0 $X=949250 $Y=-207400
X289 GNDA 10 cpolyc_CDNS_78073660103145 $T=950600 -150350 0 0 $X=949250 $Y=-151700
X290 GNDA 10 cpolyc_CDNS_78073660103145 $T=950600 -94650 0 0 $X=949250 $Y=-96000
X291 GNDA 10 ICV_61 $T=797600 -261750 0 0 $X=796250 $Y=-263100
X292 GNDA 10 ICV_61 $T=797600 -206050 0 0 $X=796250 $Y=-207400
X293 GNDA 10 ICV_61 $T=797600 -150350 0 0 $X=796250 $Y=-151700
X294 GNDA 10 ICV_61 $T=797600 -94650 0 0 $X=796250 $Y=-96000
.ENDS
***************************************
.SUBCKT ND_C_CDNS_78073660103557
** N=2 EP=0 IP=0 FDC=0
.ENDS
***************************************
.SUBCKT chopper_f clk clk~ outn outp inn inp VDDA GNDA
** N=8 EP=8 IP=40 FDC=24
X0 inp outp clk GNDA nmos4_CDNS_7807366010344 $T=4700 17650 1 270 $X=1050 $Y=7100
X1 inp outn clk~ GNDA nmos4_CDNS_7807366010344 $T=8700 17650 1 270 $X=5050 $Y=7100
X2 inn outp clk~ GNDA nmos4_CDNS_7807366010344 $T=12700 17650 1 270 $X=9050 $Y=7100
X3 inn outn clk GNDA nmos4_CDNS_7807366010344 $T=16700 17650 1 270 $X=13050 $Y=7100
X4 inp outp clk~ VDDA pmos4_CDNS_7807366010345 $T=27800 16850 1 270 $X=20500 $Y=5650
X5 inp outn clk VDDA pmos4_CDNS_7807366010345 $T=38900 16850 1 270 $X=31600 $Y=5650
X6 inn outp clk VDDA pmos4_CDNS_7807366010345 $T=50000 16850 1 270 $X=42700 $Y=5650
X7 inn outn clk~ VDDA pmos4_CDNS_7807366010345 $T=61100 16850 1 270 $X=53800 $Y=5650
.ENDS
***************************************
.SUBCKT PD_C_CDNS_78073660103569
** N=1 EP=0 IP=0 FDC=0
.ENDS
***************************************
.SUBCKT rpolyhc_CDNS_78073660103161 1
** N=1 EP=1 IP=0 FDC=1
R0 1 1 L=1.875e-05 W=2e-06 $[rpolyh] $X=600 $Y=0 $D=18
.ENDS
***************************************
.SUBCKT rpolyhc_CDNS_78073660103162 1 2
** N=3 EP=2 IP=0 FDC=1
R0 1 2 L=1.875e-05 W=2e-06 $[rpolyh] $X=600 $Y=0 $D=18
.ENDS
***************************************
.SUBCKT nmos4_CDNS_78073660103150
** N=4 EP=0 IP=0 FDC=0
.ENDS
***************************************
.SUBCKT ICV_91 1 2 5
** N=5 EP=3 IP=8 FDC=1
M0 2 5 1 1 nmos4 L=8e-05 W=8e-06 AD=6.8e-12 AS=6.8e-12 PD=9.7e-06 PS=9.7e-06 NRD=0.053125 NRS=0.053125 $X=-9250 $Y=850 $D=37
.ENDS
***************************************
.SUBCKT ICV_92 1 2 3 4 7
** N=7 EP=5 IP=10 FDC=3
M0 3 7 1 1 nmos4 L=8e-05 W=8e-06 AD=6.8e-12 AS=6.8e-12 PD=9.7e-06 PS=9.7e-06 NRD=0.053125 NRS=0.053125 $X=-18500 $Y=850 $D=37
X1 1 2 7 ICV_91 $T=-18500 0 0 0 $X=-28150 $Y=-250
X2 1 4 7 ICV_91 $T=0 0 0 0 $X=-9650 $Y=-250
.ENDS
***************************************
.SUBCKT pmos4_CDNS_78073660103158 1 2 3
** N=4 EP=3 IP=0 FDC=6
M0 2 3 1 1 pmos4 L=4e-06 W=3.335e-05 AD=1.6675e-11 AS=2.83475e-11 PD=1e-06 PS=3.505e-05 NRD=0.0127436 NRS=0.0127436 $X=0 $Y=850 $D=41
M1 1 3 2 1 pmos4 L=4e-06 W=3.335e-05 AD=1.6675e-11 AS=1.6675e-11 PD=1e-06 PS=1e-06 NRD=0.0127436 NRS=0.0127436 $X=0 $Y=5850 $D=41
M2 2 3 1 1 pmos4 L=4e-06 W=3.335e-05 AD=1.6675e-11 AS=1.6675e-11 PD=1e-06 PS=1e-06 NRD=0.0127436 NRS=0.0127436 $X=0 $Y=10850 $D=41
M3 1 3 2 1 pmos4 L=4e-06 W=3.335e-05 AD=1.6675e-11 AS=1.6675e-11 PD=1e-06 PS=1e-06 NRD=0.0127436 NRS=0.0127436 $X=0 $Y=15850 $D=41
M4 2 3 1 1 pmos4 L=4e-06 W=3.335e-05 AD=1.6675e-11 AS=1.6675e-11 PD=1e-06 PS=1e-06 NRD=0.0127436 NRS=0.0127436 $X=0 $Y=20850 $D=41
M5 1 3 2 1 pmos4 L=4e-06 W=3.335e-05 AD=2.83475e-11 AS=1.6675e-11 PD=3.505e-05 PS=1e-06 NRD=0.0127436 NRS=0.0127436 $X=0 $Y=25850 $D=41
.ENDS
***************************************
.SUBCKT P1_C_CDNS_78073660103545
** N=2 EP=0 IP=0 FDC=0
.ENDS
***************************************
.SUBCKT nmos4_CDNS_78073660103155 1 2 3 4
** N=4 EP=4 IP=0 FDC=10
M0 2 3 1 4 nmos4 L=4e-06 W=1e-06 AD=5e-13 AS=8.5e-13 PD=1e-06 PS=2.7e-06 NRD=0.425 NRS=0.425 $X=0 $Y=850 $D=37
M1 1 3 2 4 nmos4 L=4e-06 W=1e-06 AD=5e-13 AS=5e-13 PD=1e-06 PS=1e-06 NRD=0.425 NRS=0.425 $X=0 $Y=5850 $D=37
M2 2 3 1 4 nmos4 L=4e-06 W=1e-06 AD=5e-13 AS=5e-13 PD=1e-06 PS=1e-06 NRD=0.425 NRS=0.425 $X=0 $Y=10850 $D=37
M3 1 3 2 4 nmos4 L=4e-06 W=1e-06 AD=5e-13 AS=5e-13 PD=1e-06 PS=1e-06 NRD=0.425 NRS=0.425 $X=0 $Y=15850 $D=37
M4 2 3 1 4 nmos4 L=4e-06 W=1e-06 AD=5e-13 AS=5e-13 PD=1e-06 PS=1e-06 NRD=0.425 NRS=0.425 $X=0 $Y=20850 $D=37
M5 1 3 2 4 nmos4 L=4e-06 W=1e-06 AD=5e-13 AS=5e-13 PD=1e-06 PS=1e-06 NRD=0.425 NRS=0.425 $X=0 $Y=25850 $D=37
M6 2 3 1 4 nmos4 L=4e-06 W=1e-06 AD=5e-13 AS=5e-13 PD=1e-06 PS=1e-06 NRD=0.425 NRS=0.425 $X=0 $Y=30850 $D=37
M7 1 3 2 4 nmos4 L=4e-06 W=1e-06 AD=5e-13 AS=5e-13 PD=1e-06 PS=1e-06 NRD=0.425 NRS=0.425 $X=0 $Y=35850 $D=37
M8 2 3 1 4 nmos4 L=4e-06 W=1e-06 AD=5e-13 AS=5e-13 PD=1e-06 PS=1e-06 NRD=0.425 NRS=0.425 $X=0 $Y=40850 $D=37
M9 1 3 2 4 nmos4 L=4e-06 W=1e-06 AD=8.5e-13 AS=5e-13 PD=2.7e-06 PS=1e-06 NRD=0.425 NRS=0.425 $X=0 $Y=45850 $D=37
.ENDS
***************************************
.SUBCKT pmos4_CDNS_78073660103159
** N=4 EP=0 IP=0 FDC=0
.ENDS
***************************************
.SUBCKT P1_C_CDNS_78073660103541
** N=2 EP=0 IP=0 FDC=0
.ENDS
***************************************
.SUBCKT P1_C_CDNS_78073660103551
** N=2 EP=0 IP=0 FDC=0
.ENDS
***************************************
.SUBCKT pmos4_CDNS_78073660103156 1 2 3 5
** N=5 EP=4 IP=0 FDC=10
M0 2 3 1 5 pmos4 L=4e-06 W=1e-05 AD=5e-12 AS=8.5e-12 PD=1e-06 PS=1.17e-05 NRD=0.0425 NRS=0.0425 $X=0 $Y=850 $D=41
M1 1 3 2 5 pmos4 L=4e-06 W=1e-05 AD=5e-12 AS=5e-12 PD=1e-06 PS=1e-06 NRD=0.0425 NRS=0.0425 $X=0 $Y=5850 $D=41
M2 2 3 1 5 pmos4 L=4e-06 W=1e-05 AD=5e-12 AS=5e-12 PD=1e-06 PS=1e-06 NRD=0.0425 NRS=0.0425 $X=0 $Y=10850 $D=41
M3 1 3 2 5 pmos4 L=4e-06 W=1e-05 AD=5e-12 AS=5e-12 PD=1e-06 PS=1e-06 NRD=0.0425 NRS=0.0425 $X=0 $Y=15850 $D=41
M4 2 3 1 5 pmos4 L=4e-06 W=1e-05 AD=5e-12 AS=5e-12 PD=1e-06 PS=1e-06 NRD=0.0425 NRS=0.0425 $X=0 $Y=20850 $D=41
M5 1 3 2 5 pmos4 L=4e-06 W=1e-05 AD=5e-12 AS=5e-12 PD=1e-06 PS=1e-06 NRD=0.0425 NRS=0.0425 $X=0 $Y=25850 $D=41
M6 2 3 1 5 pmos4 L=4e-06 W=1e-05 AD=5e-12 AS=5e-12 PD=1e-06 PS=1e-06 NRD=0.0425 NRS=0.0425 $X=0 $Y=30850 $D=41
M7 1 3 2 5 pmos4 L=4e-06 W=1e-05 AD=5e-12 AS=5e-12 PD=1e-06 PS=1e-06 NRD=0.0425 NRS=0.0425 $X=0 $Y=35850 $D=41
M8 2 3 1 5 pmos4 L=4e-06 W=1e-05 AD=5e-12 AS=5e-12 PD=1e-06 PS=1e-06 NRD=0.0425 NRS=0.0425 $X=0 $Y=40850 $D=41
M9 1 3 2 5 pmos4 L=4e-06 W=1e-05 AD=8.5e-12 AS=5e-12 PD=1.17e-05 PS=1e-06 NRD=0.0425 NRS=0.0425 $X=0 $Y=45850 $D=41
.ENDS
***************************************
.SUBCKT ICV_90
** N=5 EP=0 IP=6 FDC=0
.ENDS
***************************************
.SUBCKT ICV_88
** N=6 EP=0 IP=8 FDC=0
.ENDS
***************************************
.SUBCKT ICV_89 1 2 3 5 6
** N=8 EP=5 IP=12 FDC=3
M0 2 5 1 1 pmos4 L=4e-06 W=1.25e-05 AD=1.0625e-11 AS=1.0625e-11 PD=1.42e-05 PS=1.42e-05 NRD=0.034 NRS=0.034 $X=0 $Y=-18050 $D=41
M1 3 6 1 1 pmos4 L=4e-06 W=1.25e-05 AD=1.0625e-11 AS=1.0625e-11 PD=1.42e-05 PS=1.42e-05 NRD=0.034 NRS=0.034 $X=0 $Y=-11750 $D=41
M2 2 5 1 1 pmos4 L=4e-06 W=1.25e-05 AD=1.0625e-11 AS=1.0625e-11 PD=1.42e-05 PS=1.42e-05 NRD=0.034 NRS=0.034 $X=0 $Y=-5450 $D=41
.ENDS
***************************************
.SUBCKT P1_C_CDNS_78073660103531
** N=2 EP=0 IP=0 FDC=0
.ENDS
***************************************
.SUBCKT rpolyhc_CDNS_78073660103164 1
** N=2 EP=1 IP=0 FDC=1
R0 1 1 L=4.99897e-06 W=8e-07 $[rpolyh] $X=600 $Y=0 $D=17
.ENDS
***************************************
.SUBCKT cpolyc_CDNS_78073660103157 2 3
** N=3 EP=2 IP=0 FDC=1
C0 2 3 $[cpolya] $A=2595.9 $P=203.8 $X=1800 $Y=1000 $D=58
.ENDS
***************************************
.SUBCKT ia_new_f GNDA 2 3 IBIAS 5 6 VDDA 8 VOUT VDDD GNDD VINN EXC1 VINP EXC2 16 17 VREF CLK
** N=42 EP=19 IP=671 FDC=368
R0 6 VOUT L=0.000749802 W=2e-06 $[rpolyh] $X=517300 $Y=211250 $D=17
D1 GNDD VDDD p_nwd AREA=79.6112 PJ=37.4 $X=3125 $Y=315825 $D=87
D2 GNDA VDDA p_nwd AREA=518.32 PJ=108.4 $X=44900 $Y=285500 $D=87
D3 GNDA VDDA p_nwd AREA=518.32 PJ=108.4 $X=45150 $Y=251600 $D=87
D4 GNDA VDDA p_nwd AREA=518.32 PJ=108.4 $X=45450 $Y=325050 $D=87
D5 GNDA GNDA p_nwd AREA=3410.5 PJ=238.6 $X=103400 $Y=296250 $D=87
D6 GNDA 2 p_nwd AREA=1211.92 PJ=139.3 $X=201050 $Y=295350 $D=87
D7 GNDA 3 p_nwd AREA=1211.92 PJ=139.3 $X=201050 $Y=334800 $D=87
D8 GNDA 3 p_nwd AREA=1208.35 PJ=139.1 $X=238100 $Y=295350 $D=87
D9 GNDA 2 p_nwd AREA=1208.35 PJ=139.1 $X=238150 $Y=334800 $D=87
D10 GNDA VDDA p_nwd AREA=5757.57 PJ=368.4 $X=299350 $Y=339700 $D=87
D11 GNDA VDDA p_nwd AREA=2603.69 PJ=274.8 $X=368350 $Y=274500 $D=87
D12 GNDA 8 p_nwd AREA=3679.14 PJ=249.6 $X=403250 $Y=157850 $D=87
D13 GNDA VDDA p_nwd AREA=33264.4 PJ=757.5 $X=504050 $Y=235100 $D=87
D14 GNDA GNDA p_nwd AREA=7246.98 PJ=542.85 $X=512400 $Y=205350 $D=87
D15 GNDA GNDA p_nwd AREA=29284.9 PJ=755.9 $X=752250 $Y=210950 $D=87
M16 31 31 31 GNDA nmos4 L=1.2e-05 W=4e-06 AD=3.4e-12 AS=3.4e-12 PD=5.7e-06 PS=5.7e-06 NRD=0.10625 NRS=0.10625 $X=50300 $Y=168050 $D=38
M17 28 28 28 GNDA nmos4 L=1.2e-05 W=4e-06 AD=3.4e-12 AS=3.4e-12 PD=5.7e-06 PS=5.7e-06 NRD=0.10625 NRS=0.10625 $X=50300 $Y=187750 $D=38
M18 31 31 31 GNDA nmos4 L=1.2e-05 W=4e-06 AD=3.4e-12 AS=3.4e-12 PD=5.7e-06 PS=5.7e-06 NRD=0.10625 NRS=0.10625 $X=97550 $Y=168050 $D=38
M19 28 28 28 GNDA nmos4 L=1.2e-05 W=4e-06 AD=3.4e-12 AS=3.4e-12 PD=5.7e-06 PS=5.7e-06 NRD=0.10625 NRS=0.10625 $X=97550 $Y=187750 $D=38
M20 29 29 29 GNDA nmos4 L=8e-05 W=8e-06 AD=6.8e-12 AS=6.8e-12 PD=9.7e-06 PS=9.7e-06 NRD=0.053125 NRS=0.053125 $X=137300 $Y=168250 $D=38
M21 29 29 29 GNDA nmos4 L=8e-05 W=8e-06 AD=6.8e-12 AS=6.8e-12 PD=9.7e-06 PS=9.7e-06 NRD=0.053125 NRS=0.053125 $X=359300 $Y=168250 $D=38
M22 GNDA GNDA GNDA GNDA nmos4 L=8e-06 W=1e-05 AD=8.5e-12 AS=8.5e-12 PD=1.17e-05 PS=1.17e-05 NRD=0.0425 NRS=0.0425 $X=392275 $Y=224250 $D=38
M23 GNDA GNDA GNDA GNDA nmos4 L=8e-06 W=1e-05 AD=8.5e-12 AS=8.5e-12 PD=1.17e-05 PS=1.17e-05 NRD=0.0425 NRS=0.0425 $X=392275 $Y=236950 $D=38
M24 GNDA GNDA GNDA GNDA nmos4 L=8e-06 W=1e-05 AD=8.5e-12 AS=8.5e-12 PD=1.17e-05 PS=1.17e-05 NRD=0.0425 NRS=0.0425 $X=443775 $Y=224250 $D=38
M25 GNDA GNDA GNDA GNDA nmos4 L=8e-06 W=1e-05 AD=8.5e-12 AS=8.5e-12 PD=1.17e-05 PS=1.17e-05 NRD=0.0425 NRS=0.0425 $X=443775 $Y=236950 $D=38
M26 IBIAS IBIAS 29 GNDA nmos4 L=8e-06 W=2e-05 AD=1.7e-11 AS=1.7e-11 PD=2.17e-05 PS=2.17e-05 NRD=0.02125 NRS=0.02125 $X=6625 $Y=225150 $D=37
M27 26 IBIAS 37 GNDA nmos4 L=8e-06 W=8e-05 AD=6.8e-11 AS=6.8e-11 PD=8.17e-05 PS=8.17e-05 NRD=0.0053125 NRS=0.0053125 $X=27225 $Y=225150 $D=37
M28 GNDA 31 24 GNDA nmos4 L=1.2e-05 W=4e-06 AD=3.4e-12 AS=3.4e-12 PD=5.7e-06 PS=5.7e-06 NRD=0.10625 NRS=0.10625 $X=71300 $Y=168050 $D=37
M29 GNDA 28 22 GNDA nmos4 L=1.2e-05 W=4e-06 AD=3.4e-12 AS=3.4e-12 PD=5.7e-06 PS=5.7e-06 NRD=0.10625 NRS=0.10625 $X=71300 $Y=187750 $D=37
M30 GNDA 31 24 GNDA nmos4 L=1.2e-05 W=4e-06 AD=3.4e-12 AS=3.4e-12 PD=5.7e-06 PS=5.7e-06 NRD=0.10625 NRS=0.10625 $X=92300 $Y=168050 $D=37
M31 GNDA 28 22 GNDA nmos4 L=1.2e-05 W=4e-06 AD=3.4e-12 AS=3.4e-12 PD=5.7e-06 PS=5.7e-06 NRD=0.10625 NRS=0.10625 $X=92300 $Y=187750 $D=37
M32 GNDA 29 31 GNDA nmos4 L=8e-05 W=8e-06 AD=6.8e-12 AS=6.8e-12 PD=9.7e-06 PS=9.7e-06 NRD=0.053125 NRS=0.053125 $X=174300 $Y=168250 $D=37
M33 GNDA 29 31 GNDA nmos4 L=8e-05 W=8e-06 AD=6.8e-12 AS=6.8e-12 PD=9.7e-06 PS=9.7e-06 NRD=0.053125 NRS=0.053125 $X=211300 $Y=168250 $D=37
M34 GNDA 29 29 GNDA nmos4 L=8e-05 W=8e-06 AD=6.8e-12 AS=6.8e-12 PD=9.7e-06 PS=9.7e-06 NRD=0.053125 NRS=0.053125 $X=248300 $Y=168250 $D=37
M35 GNDA 29 31 GNDA nmos4 L=8e-05 W=8e-06 AD=6.8e-12 AS=6.8e-12 PD=9.7e-06 PS=9.7e-06 NRD=0.053125 NRS=0.053125 $X=285300 $Y=168250 $D=37
M36 GNDA 29 31 GNDA nmos4 L=8e-05 W=8e-06 AD=6.8e-12 AS=6.8e-12 PD=9.7e-06 PS=9.7e-06 NRD=0.053125 NRS=0.053125 $X=322300 $Y=168250 $D=37
M37 GNDA 36 36 GNDA nmos4 L=8e-06 W=1e-05 AD=8.5e-12 AS=8.5e-12 PD=1.17e-05 PS=1.17e-05 NRD=0.0425 NRS=0.0425 $X=402575 $Y=224250 $D=37
M38 GNDA 36 5 GNDA nmos4 L=8e-06 W=1e-05 AD=8.5e-12 AS=8.5e-12 PD=1.17e-05 PS=1.17e-05 NRD=0.0425 NRS=0.0425 $X=402575 $Y=236950 $D=37
M39 GNDA 36 5 GNDA nmos4 L=8e-06 W=1e-05 AD=8.5e-12 AS=8.5e-12 PD=1.17e-05 PS=1.17e-05 NRD=0.0425 NRS=0.0425 $X=412875 $Y=224250 $D=37
M40 GNDA 36 36 GNDA nmos4 L=8e-06 W=1e-05 AD=8.5e-12 AS=8.5e-12 PD=1.17e-05 PS=1.17e-05 NRD=0.0425 NRS=0.0425 $X=412875 $Y=236950 $D=37
M41 GNDA 36 36 GNDA nmos4 L=8e-06 W=1e-05 AD=8.5e-12 AS=8.5e-12 PD=1.17e-05 PS=1.17e-05 NRD=0.0425 NRS=0.0425 $X=423175 $Y=224250 $D=37
M42 GNDA 36 5 GNDA nmos4 L=8e-06 W=1e-05 AD=8.5e-12 AS=8.5e-12 PD=1.17e-05 PS=1.17e-05 NRD=0.0425 NRS=0.0425 $X=423175 $Y=236950 $D=37
M43 GNDA 36 5 GNDA nmos4 L=8e-06 W=1e-05 AD=8.5e-12 AS=8.5e-12 PD=1.17e-05 PS=1.17e-05 NRD=0.0425 NRS=0.0425 $X=433475 $Y=224250 $D=37
M44 GNDA 36 36 GNDA nmos4 L=8e-06 W=1e-05 AD=8.5e-12 AS=8.5e-12 PD=1.17e-05 PS=1.17e-05 NRD=0.0425 NRS=0.0425 $X=433475 $Y=236950 $D=37
M45 VOUT 5 GNDA GNDA nmos4 L=2e-06 W=1e-05 AD=8.5e-12 AS=8.5e-12 PD=1.17e-05 PS=1.17e-05 NRD=0.0425 NRS=0.0425 $X=656375 $Y=195900 $D=37
M46 VDDA VDDA VDDA VDDA pmos4 L=2e-05 W=2.5e-05 AD=2.125e-11 AS=2.125e-11 PD=2.67e-05 PS=2.67e-05 NRD=0.017 NRS=0.017 $X=305725 $Y=349100 $D=42
M47 8 8 8 8 pmos4 L=4e-06 W=1.25e-05 AD=1.0625e-11 AS=1.0625e-11 PD=1.42e-05 PS=1.42e-05 NRD=0.034 NRS=0.034 $X=411425 $Y=166150 $D=42
M48 8 8 8 8 pmos4 L=4e-06 W=1.25e-05 AD=1.0625e-11 AS=1.0625e-11 PD=1.42e-05 PS=1.42e-05 NRD=0.034 NRS=0.034 $X=411425 $Y=184750 $D=42
M49 VDDA VDDA VDDA VDDA pmos4 L=2e-05 W=2.5e-05 AD=2.125e-11 AS=2.125e-11 PD=2.67e-05 PS=2.67e-05 NRD=0.017 NRS=0.017 $X=417225 $Y=349100 $D=42
M50 8 8 8 8 pmos4 L=4e-06 W=1.25e-05 AD=1.0625e-11 AS=1.0625e-11 PD=1.42e-05 PS=1.42e-05 NRD=0.034 NRS=0.034 $X=468125 $Y=166150 $D=42
M51 8 8 8 8 pmos4 L=4e-06 W=1.25e-05 AD=1.0625e-11 AS=1.0625e-11 PD=1.42e-05 PS=1.42e-05 NRD=0.034 NRS=0.034 $X=468125 $Y=184750 $D=42
M52 VDDA VDDA VDDA VDDA pmos4 L=1.2e-05 W=1e-05 AD=8.5e-12 AS=8.5e-12 PD=1.17e-05 PS=1.17e-05 NRD=0.0425 NRS=0.0425 $X=539575 $Y=241450 $D=42
M53 VDDA VDDA VDDA VDDA pmos4 L=1.2e-05 W=1e-05 AD=8.5e-12 AS=8.5e-12 PD=1.17e-05 PS=1.17e-05 NRD=0.0425 NRS=0.0425 $X=539575 $Y=356150 $D=42
M54 VDDA VDDA VDDA VDDA pmos4 L=1.2e-05 W=1e-05 AD=8.5e-12 AS=8.5e-12 PD=1.17e-05 PS=1.17e-05 NRD=0.0425 NRS=0.0425 $X=553875 $Y=241450 $D=42
M55 VDDA VDDA VDDA VDDA pmos4 L=1.2e-05 W=1e-05 AD=8.5e-12 AS=8.5e-12 PD=1.17e-05 PS=1.17e-05 NRD=0.0425 NRS=0.0425 $X=553875 $Y=356150 $D=42
M56 VDDA VDDA VDDA VDDA pmos4 L=1.2e-05 W=1e-05 AD=8.5e-12 AS=8.5e-12 PD=1.17e-05 PS=1.17e-05 NRD=0.0425 NRS=0.0425 $X=568175 $Y=241450 $D=42
M57 VDDA VDDA VDDA VDDA pmos4 L=1.2e-05 W=1e-05 AD=8.5e-12 AS=8.5e-12 PD=1.17e-05 PS=1.17e-05 NRD=0.0425 NRS=0.0425 $X=568175 $Y=356150 $D=42
M58 VDDA VDDA VDDA VDDA pmos4 L=1.2e-05 W=1e-05 AD=8.5e-12 AS=8.5e-12 PD=1.17e-05 PS=1.17e-05 NRD=0.0425 NRS=0.0425 $X=582475 $Y=241450 $D=42
M59 VDDA VDDA VDDA VDDA pmos4 L=1.2e-05 W=1e-05 AD=8.5e-12 AS=8.5e-12 PD=1.17e-05 PS=1.17e-05 NRD=0.0425 NRS=0.0425 $X=582475 $Y=356150 $D=42
M60 VDDA VDDA VDDA VDDA pmos4 L=1.2e-05 W=1e-05 AD=8.5e-12 AS=8.5e-12 PD=1.17e-05 PS=1.17e-05 NRD=0.0425 NRS=0.0425 $X=596775 $Y=241450 $D=42
M61 VDDA VDDA VDDA VDDA pmos4 L=1.2e-05 W=1e-05 AD=8.5e-12 AS=8.5e-12 PD=1.17e-05 PS=1.17e-05 NRD=0.0425 NRS=0.0425 $X=596775 $Y=356150 $D=42
M62 VDDA VDDA VDDA VDDA pmos4 L=1.2e-05 W=1e-05 AD=8.5e-12 AS=8.5e-12 PD=1.17e-05 PS=1.17e-05 NRD=0.0425 NRS=0.0425 $X=611075 $Y=241450 $D=42
M63 VDDA VDDA VDDA VDDA pmos4 L=1.2e-05 W=1e-05 AD=8.5e-12 AS=8.5e-12 PD=1.17e-05 PS=1.17e-05 NRD=0.0425 NRS=0.0425 $X=611075 $Y=356150 $D=42
M64 VDDA VDDA VDDA VDDA pmos4 L=1.2e-05 W=1e-05 AD=8.5e-12 AS=8.5e-12 PD=1.17e-05 PS=1.17e-05 NRD=0.0425 NRS=0.0425 $X=625375 $Y=241450 $D=42
M65 VDDA VDDA VDDA VDDA pmos4 L=1.2e-05 W=1e-05 AD=8.5e-12 AS=8.5e-12 PD=1.17e-05 PS=1.17e-05 NRD=0.0425 NRS=0.0425 $X=625375 $Y=356150 $D=42
M66 VDDA VDDA VDDA VDDA pmos4 L=1.2e-05 W=1e-05 AD=8.5e-12 AS=8.5e-12 PD=1.17e-05 PS=1.17e-05 NRD=0.0425 NRS=0.0425 $X=639675 $Y=241450 $D=42
M67 VDDA VDDA VDDA VDDA pmos4 L=1.2e-05 W=1e-05 AD=8.5e-12 AS=8.5e-12 PD=1.17e-05 PS=1.17e-05 NRD=0.0425 NRS=0.0425 $X=639675 $Y=356150 $D=42
M68 VDDA VDDA VDDA VDDA pmos4 L=1.2e-05 W=1e-05 AD=8.5e-12 AS=8.5e-12 PD=1.17e-05 PS=1.17e-05 NRD=0.0425 NRS=0.0425 $X=653975 $Y=241450 $D=42
M69 VDDA VDDA VDDA VDDA pmos4 L=1.2e-05 W=1e-05 AD=8.5e-12 AS=8.5e-12 PD=1.17e-05 PS=1.17e-05 NRD=0.0425 NRS=0.0425 $X=653975 $Y=356150 $D=42
M70 VDDA VDDA VDDA VDDA pmos4 L=1.2e-05 W=1e-05 AD=8.5e-12 AS=8.5e-12 PD=1.17e-05 PS=1.17e-05 NRD=0.0425 NRS=0.0425 $X=668275 $Y=241450 $D=42
M71 VDDA VDDA VDDA VDDA pmos4 L=1.2e-05 W=1e-05 AD=8.5e-12 AS=8.5e-12 PD=1.17e-05 PS=1.17e-05 NRD=0.0425 NRS=0.0425 $X=668275 $Y=356150 $D=42
M72 VDDA VDDA VDDA VDDA pmos4 L=1.2e-05 W=1e-05 AD=8.5e-12 AS=8.5e-12 PD=1.17e-05 PS=1.17e-05 NRD=0.0425 NRS=0.0425 $X=682575 $Y=241450 $D=42
M73 VDDA VDDA VDDA VDDA pmos4 L=1.2e-05 W=1e-05 AD=8.5e-12 AS=8.5e-12 PD=1.17e-05 PS=1.17e-05 NRD=0.0425 NRS=0.0425 $X=682575 $Y=356150 $D=42
M74 VDDA VDDA VDDA VDDA pmos4 L=1.2e-05 W=1e-05 AD=8.5e-12 AS=8.5e-12 PD=1.17e-05 PS=1.17e-05 NRD=0.0425 NRS=0.0425 $X=696875 $Y=241450 $D=42
M75 VDDA VDDA VDDA VDDA pmos4 L=1.2e-05 W=1e-05 AD=8.5e-12 AS=8.5e-12 PD=1.17e-05 PS=1.17e-05 NRD=0.0425 NRS=0.0425 $X=696875 $Y=332850 $D=42
M76 VDDA VDDA VDDA VDDA pmos4 L=1.2e-05 W=1e-05 AD=8.5e-12 AS=8.5e-12 PD=1.17e-05 PS=1.17e-05 NRD=0.0425 NRS=0.0425 $X=696875 $Y=356150 $D=42
M77 VDDA VDDA VDDA VDDA pmos4 L=1.2e-05 W=1e-05 AD=8.5e-12 AS=8.5e-12 PD=1.17e-05 PS=1.17e-05 NRD=0.0425 NRS=0.0425 $X=711175 $Y=241450 $D=42
M78 VDDA VDDA VDDA VDDA pmos4 L=1.2e-05 W=1e-05 AD=8.5e-12 AS=8.5e-12 PD=1.17e-05 PS=1.17e-05 NRD=0.0425 NRS=0.0425 $X=711175 $Y=262950 $D=42
M79 VDDA VDDA VDDA VDDA pmos4 L=1.2e-05 W=1e-05 AD=8.5e-12 AS=8.5e-12 PD=1.17e-05 PS=1.17e-05 NRD=0.0425 NRS=0.0425 $X=711175 $Y=286250 $D=42
M80 VDDA VDDA VDDA VDDA pmos4 L=1.2e-05 W=1e-05 AD=8.5e-12 AS=8.5e-12 PD=1.17e-05 PS=1.17e-05 NRD=0.0425 NRS=0.0425 $X=711175 $Y=309550 $D=42
M81 VDDA VDDA VDDA VDDA pmos4 L=1.2e-05 W=1e-05 AD=8.5e-12 AS=8.5e-12 PD=1.17e-05 PS=1.17e-05 NRD=0.0425 NRS=0.0425 $X=711175 $Y=332850 $D=42
M82 VDDA VDDA VDDA VDDA pmos4 L=1.2e-05 W=1e-05 AD=8.5e-12 AS=8.5e-12 PD=1.17e-05 PS=1.17e-05 NRD=0.0425 NRS=0.0425 $X=711175 $Y=356150 $D=42
M83 VDDA 17 17 VDDA pmos4 L=2e-05 W=2.5e-05 AD=2.125e-11 AS=2.125e-11 PD=2.67e-05 PS=2.67e-05 NRD=0.017 NRS=0.017 $X=328025 $Y=349100 $D=41
M84 VDDA 17 16 VDDA pmos4 L=2e-05 W=2.5e-05 AD=2.125e-11 AS=2.125e-11 PD=2.67e-05 PS=2.67e-05 NRD=0.017 NRS=0.017 $X=350325 $Y=349100 $D=41
M85 VDDA 17 17 VDDA pmos4 L=2e-05 W=2.5e-05 AD=2.125e-11 AS=2.125e-11 PD=2.67e-05 PS=2.67e-05 NRD=0.017 NRS=0.017 $X=372625 $Y=349100 $D=41
M86 VDDA 17 16 VDDA pmos4 L=2e-05 W=2.5e-05 AD=2.125e-11 AS=2.125e-11 PD=2.67e-05 PS=2.67e-05 NRD=0.017 NRS=0.017 $X=394925 $Y=349100 $D=41
M87 8 6 36 8 pmos4 L=4e-06 W=1.25e-05 AD=1.0625e-11 AS=1.0625e-11 PD=1.42e-05 PS=1.42e-05 NRD=0.034 NRS=0.034 $X=436625 $Y=166150 $D=41
M88 8 VREF 5 8 pmos4 L=4e-06 W=1.25e-05 AD=1.0625e-11 AS=1.0625e-11 PD=1.42e-05 PS=1.42e-05 NRD=0.034 NRS=0.034 $X=436625 $Y=184750 $D=41
M89 8 VREF 5 8 pmos4 L=4e-06 W=1.25e-05 AD=1.0625e-11 AS=1.0625e-11 PD=1.42e-05 PS=1.42e-05 NRD=0.034 NRS=0.034 $X=461825 $Y=166150 $D=41
M90 8 6 36 8 pmos4 L=4e-06 W=1.25e-05 AD=1.0625e-11 AS=1.0625e-11 PD=1.42e-05 PS=1.42e-05 NRD=0.034 NRS=0.034 $X=461825 $Y=184750 $D=41
M91 3 26 VDDA VDDA pmos4 L=1.2e-05 W=1e-05 AD=8.5e-12 AS=8.5e-12 PD=1.17e-05 PS=1.17e-05 NRD=0.0425 NRS=0.0425 $X=539575 $Y=262950 $D=41
M92 2 26 VDDA VDDA pmos4 L=1.2e-05 W=1e-05 AD=8.5e-12 AS=8.5e-12 PD=1.17e-05 PS=1.17e-05 NRD=0.0425 NRS=0.0425 $X=539575 $Y=286250 $D=41
M93 3 26 VDDA VDDA pmos4 L=1.2e-05 W=1e-05 AD=8.5e-12 AS=8.5e-12 PD=1.17e-05 PS=1.17e-05 NRD=0.0425 NRS=0.0425 $X=539575 $Y=309550 $D=41
M94 2 26 VDDA VDDA pmos4 L=1.2e-05 W=1e-05 AD=8.5e-12 AS=8.5e-12 PD=1.17e-05 PS=1.17e-05 NRD=0.0425 NRS=0.0425 $X=539575 $Y=332850 $D=41
M95 2 26 VDDA VDDA pmos4 L=1.2e-05 W=1e-05 AD=8.5e-12 AS=8.5e-12 PD=1.17e-05 PS=1.17e-05 NRD=0.0425 NRS=0.0425 $X=553875 $Y=262950 $D=41
M96 3 26 VDDA VDDA pmos4 L=1.2e-05 W=1e-05 AD=8.5e-12 AS=8.5e-12 PD=1.17e-05 PS=1.17e-05 NRD=0.0425 NRS=0.0425 $X=553875 $Y=286250 $D=41
M97 2 26 VDDA VDDA pmos4 L=1.2e-05 W=1e-05 AD=8.5e-12 AS=8.5e-12 PD=1.17e-05 PS=1.17e-05 NRD=0.0425 NRS=0.0425 $X=553875 $Y=309550 $D=41
M98 3 26 VDDA VDDA pmos4 L=1.2e-05 W=1e-05 AD=8.5e-12 AS=8.5e-12 PD=1.17e-05 PS=1.17e-05 NRD=0.0425 NRS=0.0425 $X=553875 $Y=332850 $D=41
M99 VOUT 26 VDDA VDDA pmos4 L=1.2e-05 W=1e-05 AD=8.5e-12 AS=8.5e-12 PD=1.17e-05 PS=1.17e-05 NRD=0.0425 NRS=0.0425 $X=568175 $Y=262950 $D=41
M100 2 26 VDDA VDDA pmos4 L=1.2e-05 W=1e-05 AD=8.5e-12 AS=8.5e-12 PD=1.17e-05 PS=1.17e-05 NRD=0.0425 NRS=0.0425 $X=568175 $Y=286250 $D=41
M101 3 26 VDDA VDDA pmos4 L=1.2e-05 W=1e-05 AD=8.5e-12 AS=8.5e-12 PD=1.17e-05 PS=1.17e-05 NRD=0.0425 NRS=0.0425 $X=568175 $Y=309550 $D=41
M102 2 26 VDDA VDDA pmos4 L=1.2e-05 W=1e-05 AD=8.5e-12 AS=8.5e-12 PD=1.17e-05 PS=1.17e-05 NRD=0.0425 NRS=0.0425 $X=568175 $Y=332850 $D=41
M103 VOUT 26 VDDA VDDA pmos4 L=1.2e-05 W=1e-05 AD=8.5e-12 AS=8.5e-12 PD=1.17e-05 PS=1.17e-05 NRD=0.0425 NRS=0.0425 $X=582475 $Y=262950 $D=41
M104 26 26 VDDA VDDA pmos4 L=1.2e-05 W=1e-05 AD=8.5e-12 AS=8.5e-12 PD=1.17e-05 PS=1.17e-05 NRD=0.0425 NRS=0.0425 $X=582475 $Y=286250 $D=41
M105 2 26 VDDA VDDA pmos4 L=1.2e-05 W=1e-05 AD=8.5e-12 AS=8.5e-12 PD=1.17e-05 PS=1.17e-05 NRD=0.0425 NRS=0.0425 $X=582475 $Y=309550 $D=41
M106 3 26 VDDA VDDA pmos4 L=1.2e-05 W=1e-05 AD=8.5e-12 AS=8.5e-12 PD=1.17e-05 PS=1.17e-05 NRD=0.0425 NRS=0.0425 $X=582475 $Y=332850 $D=41
M107 VOUT 26 VDDA VDDA pmos4 L=1.2e-05 W=1e-05 AD=8.5e-12 AS=8.5e-12 PD=1.17e-05 PS=1.17e-05 NRD=0.0425 NRS=0.0425 $X=596775 $Y=262950 $D=41
M108 2 26 VDDA VDDA pmos4 L=1.2e-05 W=1e-05 AD=8.5e-12 AS=8.5e-12 PD=1.17e-05 PS=1.17e-05 NRD=0.0425 NRS=0.0425 $X=596775 $Y=286250 $D=41
M109 8 26 VDDA VDDA pmos4 L=1.2e-05 W=1e-05 AD=8.5e-12 AS=8.5e-12 PD=1.17e-05 PS=1.17e-05 NRD=0.0425 NRS=0.0425 $X=596775 $Y=309550 $D=41
M110 2 26 VDDA VDDA pmos4 L=1.2e-05 W=1e-05 AD=8.5e-12 AS=8.5e-12 PD=1.17e-05 PS=1.17e-05 NRD=0.0425 NRS=0.0425 $X=596775 $Y=332850 $D=41
M111 VOUT 26 VDDA VDDA pmos4 L=1.2e-05 W=1e-05 AD=8.5e-12 AS=8.5e-12 PD=1.17e-05 PS=1.17e-05 NRD=0.0425 NRS=0.0425 $X=611075 $Y=262950 $D=41
M112 3 26 VDDA VDDA pmos4 L=1.2e-05 W=1e-05 AD=8.5e-12 AS=8.5e-12 PD=1.17e-05 PS=1.17e-05 NRD=0.0425 NRS=0.0425 $X=611075 $Y=286250 $D=41
M113 8 26 VDDA VDDA pmos4 L=1.2e-05 W=1e-05 AD=8.5e-12 AS=8.5e-12 PD=1.17e-05 PS=1.17e-05 NRD=0.0425 NRS=0.0425 $X=611075 $Y=309550 $D=41
M114 3 26 VDDA VDDA pmos4 L=1.2e-05 W=1e-05 AD=8.5e-12 AS=8.5e-12 PD=1.17e-05 PS=1.17e-05 NRD=0.0425 NRS=0.0425 $X=611075 $Y=332850 $D=41
M115 VOUT 26 VDDA VDDA pmos4 L=1.2e-05 W=1e-05 AD=8.5e-12 AS=8.5e-12 PD=1.17e-05 PS=1.17e-05 NRD=0.0425 NRS=0.0425 $X=625375 $Y=262950 $D=41
M116 2 26 VDDA VDDA pmos4 L=1.2e-05 W=1e-05 AD=8.5e-12 AS=8.5e-12 PD=1.17e-05 PS=1.17e-05 NRD=0.0425 NRS=0.0425 $X=625375 $Y=286250 $D=41
M117 8 26 VDDA VDDA pmos4 L=1.2e-05 W=1e-05 AD=8.5e-12 AS=8.5e-12 PD=1.17e-05 PS=1.17e-05 NRD=0.0425 NRS=0.0425 $X=625375 $Y=309550 $D=41
M118 2 26 VDDA VDDA pmos4 L=1.2e-05 W=1e-05 AD=8.5e-12 AS=8.5e-12 PD=1.17e-05 PS=1.17e-05 NRD=0.0425 NRS=0.0425 $X=625375 $Y=332850 $D=41
M119 VOUT 26 VDDA VDDA pmos4 L=1.2e-05 W=1e-05 AD=8.5e-12 AS=8.5e-12 PD=1.17e-05 PS=1.17e-05 NRD=0.0425 NRS=0.0425 $X=639675 $Y=262950 $D=41
M120 3 26 VDDA VDDA pmos4 L=1.2e-05 W=1e-05 AD=8.5e-12 AS=8.5e-12 PD=1.17e-05 PS=1.17e-05 NRD=0.0425 NRS=0.0425 $X=639675 $Y=286250 $D=41
M121 8 26 VDDA VDDA pmos4 L=1.2e-05 W=1e-05 AD=8.5e-12 AS=8.5e-12 PD=1.17e-05 PS=1.17e-05 NRD=0.0425 NRS=0.0425 $X=639675 $Y=309550 $D=41
M122 3 26 VDDA VDDA pmos4 L=1.2e-05 W=1e-05 AD=8.5e-12 AS=8.5e-12 PD=1.17e-05 PS=1.17e-05 NRD=0.0425 NRS=0.0425 $X=639675 $Y=332850 $D=41
M123 VOUT 26 VDDA VDDA pmos4 L=1.2e-05 W=1e-05 AD=8.5e-12 AS=8.5e-12 PD=1.17e-05 PS=1.17e-05 NRD=0.0425 NRS=0.0425 $X=653975 $Y=262950 $D=41
M124 2 26 VDDA VDDA pmos4 L=1.2e-05 W=1e-05 AD=8.5e-12 AS=8.5e-12 PD=1.17e-05 PS=1.17e-05 NRD=0.0425 NRS=0.0425 $X=653975 $Y=286250 $D=41
M125 8 26 VDDA VDDA pmos4 L=1.2e-05 W=1e-05 AD=8.5e-12 AS=8.5e-12 PD=1.17e-05 PS=1.17e-05 NRD=0.0425 NRS=0.0425 $X=653975 $Y=309550 $D=41
M126 3 26 VDDA VDDA pmos4 L=1.2e-05 W=1e-05 AD=8.5e-12 AS=8.5e-12 PD=1.17e-05 PS=1.17e-05 NRD=0.0425 NRS=0.0425 $X=653975 $Y=332850 $D=41
M127 VOUT 26 VDDA VDDA pmos4 L=1.2e-05 W=1e-05 AD=8.5e-12 AS=8.5e-12 PD=1.17e-05 PS=1.17e-05 NRD=0.0425 NRS=0.0425 $X=668275 $Y=262950 $D=41
M128 3 26 VDDA VDDA pmos4 L=1.2e-05 W=1e-05 AD=8.5e-12 AS=8.5e-12 PD=1.17e-05 PS=1.17e-05 NRD=0.0425 NRS=0.0425 $X=668275 $Y=286250 $D=41
M129 26 26 VDDA VDDA pmos4 L=1.2e-05 W=1e-05 AD=8.5e-12 AS=8.5e-12 PD=1.17e-05 PS=1.17e-05 NRD=0.0425 NRS=0.0425 $X=668275 $Y=309550 $D=41
M130 3 26 VDDA VDDA pmos4 L=1.2e-05 W=1e-05 AD=8.5e-12 AS=8.5e-12 PD=1.17e-05 PS=1.17e-05 NRD=0.0425 NRS=0.0425 $X=668275 $Y=332850 $D=41
M131 VOUT 26 VDDA VDDA pmos4 L=1.2e-05 W=1e-05 AD=8.5e-12 AS=8.5e-12 PD=1.17e-05 PS=1.17e-05 NRD=0.0425 NRS=0.0425 $X=682575 $Y=262950 $D=41
M132 2 26 VDDA VDDA pmos4 L=1.2e-05 W=1e-05 AD=8.5e-12 AS=8.5e-12 PD=1.17e-05 PS=1.17e-05 NRD=0.0425 NRS=0.0425 $X=682575 $Y=286250 $D=41
M133 3 26 VDDA VDDA pmos4 L=1.2e-05 W=1e-05 AD=8.5e-12 AS=8.5e-12 PD=1.17e-05 PS=1.17e-05 NRD=0.0425 NRS=0.0425 $X=682575 $Y=309550 $D=41
M134 2 26 VDDA VDDA pmos4 L=1.2e-05 W=1e-05 AD=8.5e-12 AS=8.5e-12 PD=1.17e-05 PS=1.17e-05 NRD=0.0425 NRS=0.0425 $X=682575 $Y=332850 $D=41
M135 VOUT 26 VDDA VDDA pmos4 L=1.2e-05 W=1e-05 AD=8.5e-12 AS=8.5e-12 PD=1.17e-05 PS=1.17e-05 NRD=0.0425 NRS=0.0425 $X=696875 $Y=262950 $D=41
M136 3 26 VDDA VDDA pmos4 L=1.2e-05 W=1e-05 AD=8.5e-12 AS=8.5e-12 PD=1.17e-05 PS=1.17e-05 NRD=0.0425 NRS=0.0425 $X=696875 $Y=286250 $D=41
M137 2 26 VDDA VDDA pmos4 L=1.2e-05 W=1e-05 AD=8.5e-12 AS=8.5e-12 PD=1.17e-05 PS=1.17e-05 NRD=0.0425 NRS=0.0425 $X=696875 $Y=309550 $D=41
C138 GNDA IBIAS $[cpolya] $A=1080 $P=156 $X=10850 $Y=143000 $D=58
C139 VOUT 5 $[cpolya] $A=2306.26 $P=192.1 $X=585325 $Y=152300 $D=58
X140 VDDD 21 CLK pmos4_CDNS_7807366010349 $T=4325 318425 0 270 $X=3125 $Y=315825
X141 VDDD 23 21 pmos4_CDNS_7807366010349 $T=11925 318425 0 270 $X=10725 $Y=315825
X142 GNDD 21 CLK nmos4_CDNS_7807366010348 $T=4325 312825 0 270 $X=4075 $Y=311625
X143 GNDD 23 21 nmos4_CDNS_7807366010348 $T=11925 312925 0 270 $X=11675 $Y=311725
X154 GNDA 33 24 31 ICV_94 $T=50300 180900 1 0 $X=49900 $Y=166950
X155 GNDA 32 22 28 ICV_94 $T=50300 200600 1 0 $X=49900 $Y=186650
X156 GNDA 33 24 31 ICV_94 $T=71300 180900 1 0 $X=70900 $Y=166950
X157 GNDA 32 22 28 ICV_94 $T=71300 200600 1 0 $X=70900 $Y=186650
X170 VDDA ICV_87 $T=524425 251450 0 270 $X=523225 $Y=240250
X171 VDDA ICV_87 $T=524425 272950 0 270 $X=523225 $Y=261750
X172 VDDA ICV_87 $T=524425 296250 0 270 $X=523225 $Y=285050
X173 VDDA ICV_87 $T=524425 319550 0 270 $X=523225 $Y=308350
X174 VDDA ICV_87 $T=524425 342850 0 270 $X=523225 $Y=331650
X175 VDDA ICV_87 $T=524425 366150 0 270 $X=523225 $Y=354950
X179 23 21 22 24 25 34 VDDA GNDA chopper_f $T=24400 279850 0 0 $X=21150 $Y=280350
X180 23 21 EXC2 EXC1 30 27 VDDA GNDA chopper_f $T=24650 245950 0 0 $X=21400 $Y=246450
X181 23 21 38 39 VINP VINN VDDA GNDA chopper_f $T=24950 319400 0 0 $X=21700 $Y=319900
X184 GNDA rpolyhc_CDNS_78073660103161 $T=112150 303550 0 0 $X=104950 $Y=297800
X185 GNDA rpolyhc_CDNS_78073660103161 $T=112150 334450 0 0 $X=104950 $Y=328700
X186 GNDA rpolyhc_CDNS_78073660103161 $T=146500 303550 0 0 $X=139300 $Y=297800
X187 GNDA rpolyhc_CDNS_78073660103161 $T=146500 334450 0 0 $X=139300 $Y=328700
X188 27 3 rpolyhc_CDNS_78073660103162 $T=114550 314650 0 0 $X=109750 $Y=311300
X189 27 3 rpolyhc_CDNS_78073660103162 $T=114550 323350 0 0 $X=109750 $Y=320000
X190 2 30 rpolyhc_CDNS_78073660103162 $T=144100 314650 0 0 $X=139300 $Y=311300
X191 2 30 rpolyhc_CDNS_78073660103162 $T=144100 323350 0 0 $X=139300 $Y=320000
X193 GNDA 28 31 37 29 ICV_92 $T=145300 249100 0 180 $X=136900 $Y=167150
X194 GNDA 28 31 28 29 ICV_92 $T=182300 249100 0 180 $X=173900 $Y=167150
X195 GNDA 28 31 28 29 ICV_92 $T=219300 249100 0 180 $X=210900 $Y=167150
X196 GNDA 28 31 28 29 ICV_92 $T=256300 249100 0 180 $X=247900 $Y=167150
X197 GNDA 28 31 28 29 ICV_92 $T=293300 249100 0 180 $X=284900 $Y=167150
X198 GNDA 37 31 28 29 ICV_92 $T=330300 249100 0 180 $X=321900 $Y=167150
X199 2 28 38 pmos4_CDNS_78073660103158 $T=233300 296550 0 90 $X=201400 $Y=295350
X200 3 31 39 pmos4_CDNS_78073660103158 $T=233300 369350 1 270 $X=201400 $Y=334800
X201 3 31 39 pmos4_CDNS_78073660103158 $T=270400 296550 0 90 $X=238500 $Y=295350
X202 2 28 38 pmos4_CDNS_78073660103158 $T=270400 369350 1 270 $X=238500 $Y=334800
X207 25 6 IBIAS GNDA nmos4_CDNS_78073660103155 $T=351425 276550 0 90 $X=300475 $Y=275750
X208 32 2 IBIAS GNDA nmos4_CDNS_78073660103155 $T=351425 284650 0 90 $X=300475 $Y=283850
X209 34 35 IBIAS GNDA nmos4_CDNS_78073660103155 $T=351425 292750 0 90 $X=300475 $Y=291950
X210 33 3 IBIAS GNDA nmos4_CDNS_78073660103155 $T=351425 300850 0 90 $X=300475 $Y=300050
X229 16 6 35 VDDA pmos4_CDNS_78073660103156 $T=374675 290850 0 270 $X=373475 $Y=279650
X230 17 35 35 VDDA pmos4_CDNS_78073660103156 $T=425975 290850 0 270 $X=424775 $Y=279650
X239 8 5 36 VREF 6 ICV_89 $T=416275 166150 0 90 $X=409375 $Y=164950
X240 8 36 5 6 VREF ICV_89 $T=416275 184750 0 90 $X=409375 $Y=183550
X241 8 36 5 6 VREF ICV_89 $T=441475 166150 0 90 $X=434575 $Y=164950
X242 8 5 36 VREF 6 ICV_89 $T=441475 184750 0 90 $X=434575 $Y=183550
X327 40 rpolyhc_CDNS_78073660103164 $T=641750 150250 0 0 $X=637750 $Y=146800
X328 41 rpolyhc_CDNS_78073660103164 $T=765550 195750 0 0 $X=761550 $Y=192300
X329 42 rpolyhc_CDNS_78073660103164 $T=840150 195200 0 0 $X=836150 $Y=191750
X330 VOUT 6 cpolyc_CDNS_78073660103157 $T=753600 212300 0 0 $X=752250 $Y=210950
X331 VOUT 6 cpolyc_CDNS_78073660103157 $T=753600 268600 0 0 $X=752250 $Y=267250
X332 VOUT 6 cpolyc_CDNS_78073660103157 $T=753600 324900 0 0 $X=752250 $Y=323550
X333 VOUT 6 cpolyc_CDNS_78073660103157 $T=810600 212300 0 0 $X=809250 $Y=210950
X334 VOUT 6 cpolyc_CDNS_78073660103157 $T=810600 268600 0 0 $X=809250 $Y=267250
X335 VOUT 6 cpolyc_CDNS_78073660103157 $T=810600 324900 0 0 $X=809250 $Y=323550
X336 VOUT 6 cpolyc_CDNS_78073660103157 $T=867600 212300 0 0 $X=866250 $Y=210950
X337 VOUT 6 cpolyc_CDNS_78073660103157 $T=867600 268600 0 0 $X=866250 $Y=267250
X338 VOUT 6 cpolyc_CDNS_78073660103157 $T=867600 324900 0 0 $X=866250 $Y=323550
.ENDS
***************************************
.SUBCKT P1_C_CDNS_78073660103588
** N=2 EP=0 IP=0 FDC=0
.ENDS
***************************************
.SUBCKT ND_C_CDNS_78073660103589
** N=2 EP=0 IP=0 FDC=0
.ENDS
***************************************
.SUBCKT nmos4_CDNS_78073660103165 1 2 3 4
** N=4 EP=4 IP=0 FDC=4
M0 2 3 1 4 nmos4 L=8e-06 W=5e-06 AD=2.5e-12 AS=4.25e-12 PD=1e-06 PS=6.7e-06 NRD=0.085 NRS=0.085 $X=0 $Y=850 $D=37
M1 1 3 2 4 nmos4 L=8e-06 W=5e-06 AD=2.5e-12 AS=2.5e-12 PD=1e-06 PS=1e-06 NRD=0.085 NRS=0.085 $X=0 $Y=9850 $D=37
M2 2 3 1 4 nmos4 L=8e-06 W=5e-06 AD=2.5e-12 AS=2.5e-12 PD=1e-06 PS=1e-06 NRD=0.085 NRS=0.085 $X=0 $Y=18850 $D=37
M3 1 3 2 4 nmos4 L=8e-06 W=5e-06 AD=4.25e-12 AS=2.5e-12 PD=6.7e-06 PS=1e-06 NRD=0.085 NRS=0.085 $X=0 $Y=27850 $D=37
.ENDS
***************************************
.SUBCKT nmos4_CDNS_78073660103168
** N=3 EP=0 IP=0 FDC=0
.ENDS
***************************************
.SUBCKT ICV_55
** N=5 EP=0 IP=6 FDC=0
.ENDS
***************************************
.SUBCKT pmos4_CDNS_78073660103169
** N=4 EP=0 IP=0 FDC=0
.ENDS
***************************************
.SUBCKT ICV_56
** N=6 EP=0 IP=8 FDC=0
.ENDS
***************************************
.SUBCKT ICV_57 1 3 4 7 8
** N=10 EP=5 IP=12 FDC=2
M0 3 7 1 1 pmos4 L=4e-06 W=1e-05 AD=8.5e-12 AS=8.5e-12 PD=1.17e-05 PS=1.17e-05 NRD=0.0425 NRS=0.0425 $X=0 $Y=-11750 $D=41
M1 4 8 1 1 pmos4 L=4e-06 W=1e-05 AD=8.5e-12 AS=8.5e-12 PD=1.17e-05 PS=1.17e-05 NRD=0.0425 NRS=0.0425 $X=0 $Y=-5450 $D=41
.ENDS
***************************************
.SUBCKT P2_C_CDNS_78073660103595
** N=2 EP=0 IP=0 FDC=0
.ENDS
***************************************
.SUBCKT mux21 A0 S C GNDA VDDA
** N=7 EP=5 IP=25 FDC=10
D0 GNDA VDDA p_nwd AREA=23.625 PJ=19.5 $X=2300 $Y=10500 $D=87
D1 GNDA VDDA p_nwd AREA=197.12 PJ=56.4 $X=7850 $Y=2100 $D=87
X2 VDDA 7 S pmos4_CDNS_7807366010349 $T=3525 13100 0 270 $X=2325 $Y=10500
X3 GNDA 7 S nmos4_CDNS_7807366010348 $T=3525 9125 0 270 $X=3275 $Y=7925
X4 A0 C S VDDA pmos4_CDNS_7807366010367 $T=13950 4800 0 90 $X=9350 $Y=3600
X5 A1 C 7 VDDA pmos4_CDNS_7807366010367 $T=17950 4800 0 90 $X=13350 $Y=3600
X6 C A1 S GNDA nmos4_CDNS_7807366010366 $T=23900 4800 0 90 $X=21600 $Y=4400
X7 C A0 7 GNDA nmos4_CDNS_7807366010366 $T=25000 4800 1 90 $X=24750 $Y=4400
.ENDS
***************************************
.SUBCKT cpolyc_CDNS_78073660103167 2 3
** N=3 EP=2 IP=0 FDC=1
C0 2 3 $[cpolya] $A=1230.11 $P=140.3 $X=1800 $Y=1000 $D=58
.ENDS
***************************************
.SUBCKT rpolyhc_CDNS_78073660103166 1
** N=2 EP=1 IP=0 FDC=1
R0 1 1 L=4.99897e-06 W=8e-07 $[rpolyh] $X=600 $Y=0 $D=17
.ENDS
***************************************
.SUBCKT VGA_1 VOUT VDDA 3 IBIAS GNDA VIN S<0> CVGA 9 S<1> S<2> 12 S<3>
** N=35 EP=13 IP=548 FDC=240
R0 17 12 L=0.00015005 W=2e-06 $[rpolyh] $X=357800 $Y=20625 $D=18
D1 GNDA VDDA p_nwd AREA=49208.1 PJ=902.6 $X=3975 $Y=-4625 $D=87
D2 GNDA 15 p_nwd AREA=5133.15 PJ=306.4 $X=281975 $Y=128550 $D=87
D3 GNDA GNDA p_nwd AREA=844.025 PJ=116.7 $X=353500 $Y=15975 $D=87
D4 GNDA 16 p_nwd AREA=718.23 PJ=107.2 $X=364275 $Y=45475 $D=87
D5 GNDA GNDA p_nwd AREA=17893.7 PJ=584 $X=418700 $Y=10850 $D=87
D6 GNDA GNDA p_nwd AREA=10153.5 PJ=438.05 $X=430525 $Y=101350 $D=87
D7 GNDA GNDA p_nwd AREA=2745.62 PJ=228.2 $X=564200 $Y=133450 $D=87
M8 GNDA GNDA GNDA GNDA nmos4 L=1.5e-05 W=7.5e-06 AD=6.375e-12 AS=6.375e-12 PD=9.2e-06 PS=9.2e-06 NRD=0.0566667 NRS=0.0566667 $X=292425 $Y=85550 $D=38
M9 GNDA GNDA GNDA GNDA nmos4 L=1.5e-05 W=7.5e-06 AD=6.375e-12 AS=6.375e-12 PD=9.2e-06 PS=9.2e-06 NRD=0.0566667 NRS=0.0566667 $X=292425 $Y=97850 $D=38
M10 GNDA GNDA GNDA GNDA nmos4 L=1.5e-05 W=7.5e-06 AD=6.375e-12 AS=6.375e-12 PD=9.2e-06 PS=9.2e-06 NRD=0.0566667 NRS=0.0566667 $X=378925 $Y=85550 $D=38
M11 GNDA GNDA GNDA GNDA nmos4 L=1.5e-05 W=7.5e-06 AD=6.375e-12 AS=6.375e-12 PD=9.2e-06 PS=9.2e-06 NRD=0.0566667 NRS=0.0566667 $X=378925 $Y=97850 $D=38
M12 3 3 GNDA GNDA nmos4 L=1.5e-05 W=7.5e-06 AD=6.375e-12 AS=6.375e-12 PD=9.2e-06 PS=9.2e-06 NRD=0.0566667 NRS=0.0566667 $X=309725 $Y=85550 $D=37
M13 17 3 GNDA GNDA nmos4 L=1.5e-05 W=7.5e-06 AD=6.375e-12 AS=6.375e-12 PD=9.2e-06 PS=9.2e-06 NRD=0.0566667 NRS=0.0566667 $X=309725 $Y=97850 $D=37
M14 17 3 GNDA GNDA nmos4 L=1.5e-05 W=7.5e-06 AD=6.375e-12 AS=6.375e-12 PD=9.2e-06 PS=9.2e-06 NRD=0.0566667 NRS=0.0566667 $X=327025 $Y=85550 $D=37
M15 3 3 GNDA GNDA nmos4 L=1.5e-05 W=7.5e-06 AD=6.375e-12 AS=6.375e-12 PD=9.2e-06 PS=9.2e-06 NRD=0.0566667 NRS=0.0566667 $X=327025 $Y=97850 $D=37
M16 17 3 GNDA GNDA nmos4 L=1.5e-05 W=7.5e-06 AD=6.375e-12 AS=6.375e-12 PD=9.2e-06 PS=9.2e-06 NRD=0.0566667 NRS=0.0566667 $X=344325 $Y=85550 $D=37
M17 3 3 GNDA GNDA nmos4 L=1.5e-05 W=7.5e-06 AD=6.375e-12 AS=6.375e-12 PD=9.2e-06 PS=9.2e-06 NRD=0.0566667 NRS=0.0566667 $X=344325 $Y=97850 $D=37
M18 3 3 GNDA GNDA nmos4 L=1.5e-05 W=7.5e-06 AD=6.375e-12 AS=6.375e-12 PD=9.2e-06 PS=9.2e-06 NRD=0.0566667 NRS=0.0566667 $X=361625 $Y=85550 $D=37
M19 17 3 GNDA GNDA nmos4 L=1.5e-05 W=7.5e-06 AD=6.375e-12 AS=6.375e-12 PD=9.2e-06 PS=9.2e-06 NRD=0.0566667 NRS=0.0566667 $X=361625 $Y=97850 $D=37
M20 VDDA VDDA VDDA VDDA pmos4 L=1.5e-05 W=1e-05 AD=8.5e-12 AS=8.5e-12 PD=1.17e-05 PS=1.17e-05 NRD=0.0425 NRS=0.0425 $X=43475 $Y=2725 $D=42
M21 VDDA VDDA VDDA VDDA pmos4 L=1.5e-05 W=1e-05 AD=8.5e-12 AS=8.5e-12 PD=1.17e-05 PS=1.17e-05 NRD=0.0425 NRS=0.0425 $X=43475 $Y=24525 $D=42
M22 VDDA VDDA VDDA VDDA pmos4 L=1.5e-05 W=1e-05 AD=8.5e-12 AS=8.5e-12 PD=1.17e-05 PS=1.17e-05 NRD=0.0425 NRS=0.0425 $X=43475 $Y=133525 $D=42
M23 VDDA VDDA VDDA VDDA pmos4 L=1.5e-05 W=1e-05 AD=8.5e-12 AS=8.5e-12 PD=1.17e-05 PS=1.17e-05 NRD=0.0425 NRS=0.0425 $X=43475 $Y=155325 $D=42
M24 VDDA VDDA VDDA VDDA pmos4 L=1.5e-05 W=1e-05 AD=8.5e-12 AS=8.5e-12 PD=1.17e-05 PS=1.17e-05 NRD=0.0425 NRS=0.0425 $X=60775 $Y=2725 $D=42
M25 VDDA VDDA VDDA VDDA pmos4 L=1.5e-05 W=1e-05 AD=8.5e-12 AS=8.5e-12 PD=1.17e-05 PS=1.17e-05 NRD=0.0425 NRS=0.0425 $X=60775 $Y=155325 $D=42
M26 VDDA VDDA VDDA VDDA pmos4 L=1.5e-05 W=1e-05 AD=8.5e-12 AS=8.5e-12 PD=1.17e-05 PS=1.17e-05 NRD=0.0425 NRS=0.0425 $X=78075 $Y=2725 $D=42
M27 VDDA VDDA VDDA VDDA pmos4 L=1.5e-05 W=1e-05 AD=8.5e-12 AS=8.5e-12 PD=1.17e-05 PS=1.17e-05 NRD=0.0425 NRS=0.0425 $X=78075 $Y=155325 $D=42
M28 VDDA VDDA VDDA VDDA pmos4 L=1.5e-05 W=1e-05 AD=8.5e-12 AS=8.5e-12 PD=1.17e-05 PS=1.17e-05 NRD=0.0425 NRS=0.0425 $X=95375 $Y=2725 $D=42
M29 VDDA VDDA VDDA VDDA pmos4 L=1.5e-05 W=1e-05 AD=8.5e-12 AS=8.5e-12 PD=1.17e-05 PS=1.17e-05 NRD=0.0425 NRS=0.0425 $X=95375 $Y=155325 $D=42
M30 VDDA VDDA VDDA VDDA pmos4 L=1.5e-05 W=1e-05 AD=8.5e-12 AS=8.5e-12 PD=1.17e-05 PS=1.17e-05 NRD=0.0425 NRS=0.0425 $X=112675 $Y=2725 $D=42
M31 VDDA VDDA VDDA VDDA pmos4 L=1.5e-05 W=1e-05 AD=8.5e-12 AS=8.5e-12 PD=1.17e-05 PS=1.17e-05 NRD=0.0425 NRS=0.0425 $X=112675 $Y=155325 $D=42
M32 VDDA VDDA VDDA VDDA pmos4 L=1.5e-05 W=1e-05 AD=8.5e-12 AS=8.5e-12 PD=1.17e-05 PS=1.17e-05 NRD=0.0425 NRS=0.0425 $X=129975 $Y=2725 $D=42
M33 VDDA VDDA VDDA VDDA pmos4 L=1.5e-05 W=1e-05 AD=8.5e-12 AS=8.5e-12 PD=1.17e-05 PS=1.17e-05 NRD=0.0425 NRS=0.0425 $X=129975 $Y=155325 $D=42
M34 VDDA VDDA VDDA VDDA pmos4 L=1.5e-05 W=1e-05 AD=8.5e-12 AS=8.5e-12 PD=1.17e-05 PS=1.17e-05 NRD=0.0425 NRS=0.0425 $X=147275 $Y=2725 $D=42
M35 VDDA VDDA VDDA VDDA pmos4 L=1.5e-05 W=1e-05 AD=8.5e-12 AS=8.5e-12 PD=1.17e-05 PS=1.17e-05 NRD=0.0425 NRS=0.0425 $X=147275 $Y=155325 $D=42
M36 VDDA VDDA VDDA VDDA pmos4 L=1.5e-05 W=1e-05 AD=8.5e-12 AS=8.5e-12 PD=1.17e-05 PS=1.17e-05 NRD=0.0425 NRS=0.0425 $X=164575 $Y=2725 $D=42
M37 VDDA VDDA VDDA VDDA pmos4 L=1.5e-05 W=1e-05 AD=8.5e-12 AS=8.5e-12 PD=1.17e-05 PS=1.17e-05 NRD=0.0425 NRS=0.0425 $X=164575 $Y=155325 $D=42
M38 VDDA VDDA VDDA VDDA pmos4 L=1.5e-05 W=1e-05 AD=8.5e-12 AS=8.5e-12 PD=1.17e-05 PS=1.17e-05 NRD=0.0425 NRS=0.0425 $X=181875 $Y=2725 $D=42
M39 VDDA VDDA VDDA VDDA pmos4 L=1.5e-05 W=1e-05 AD=8.5e-12 AS=8.5e-12 PD=1.17e-05 PS=1.17e-05 NRD=0.0425 NRS=0.0425 $X=181875 $Y=155325 $D=42
M40 VDDA VDDA VDDA VDDA pmos4 L=1.5e-05 W=1e-05 AD=8.5e-12 AS=8.5e-12 PD=1.17e-05 PS=1.17e-05 NRD=0.0425 NRS=0.0425 $X=199175 $Y=2725 $D=42
M41 VDDA VDDA VDDA VDDA pmos4 L=1.5e-05 W=1e-05 AD=8.5e-12 AS=8.5e-12 PD=1.17e-05 PS=1.17e-05 NRD=0.0425 NRS=0.0425 $X=199175 $Y=155325 $D=42
M42 VDDA VDDA VDDA VDDA pmos4 L=1.5e-05 W=1e-05 AD=8.5e-12 AS=8.5e-12 PD=1.17e-05 PS=1.17e-05 NRD=0.0425 NRS=0.0425 $X=216475 $Y=2725 $D=42
M43 VDDA VDDA VDDA VDDA pmos4 L=1.5e-05 W=1e-05 AD=8.5e-12 AS=8.5e-12 PD=1.17e-05 PS=1.17e-05 NRD=0.0425 NRS=0.0425 $X=216475 $Y=133525 $D=42
M44 VDDA VDDA VDDA VDDA pmos4 L=1.5e-05 W=1e-05 AD=8.5e-12 AS=8.5e-12 PD=1.17e-05 PS=1.17e-05 NRD=0.0425 NRS=0.0425 $X=216475 $Y=155325 $D=42
M45 15 15 15 15 pmos4 L=4e-06 W=1e-05 AD=8.5e-12 AS=8.5e-12 PD=1.17e-05 PS=1.17e-05 NRD=0.0425 NRS=0.0425 $X=297175 $Y=139900 $D=42
M46 15 15 15 15 pmos4 L=4e-06 W=1e-05 AD=8.5e-12 AS=8.5e-12 PD=1.17e-05 PS=1.17e-05 NRD=0.0425 NRS=0.0425 $X=297175 $Y=156700 $D=42
M47 15 15 15 15 pmos4 L=4e-06 W=1e-05 AD=8.5e-12 AS=8.5e-12 PD=1.17e-05 PS=1.17e-05 NRD=0.0425 NRS=0.0425 $X=366475 $Y=139900 $D=42
M48 15 15 15 15 pmos4 L=4e-06 W=1e-05 AD=8.5e-12 AS=8.5e-12 PD=1.17e-05 PS=1.17e-05 NRD=0.0425 NRS=0.0425 $X=366475 $Y=156700 $D=42
M49 VDDA 14 VOUT VDDA pmos4 L=1.5e-05 W=1e-05 AD=8.5e-12 AS=8.5e-12 PD=1.17e-05 PS=1.17e-05 NRD=0.0425 NRS=0.0425 $X=43475 $Y=46325 $D=41
M50 VDDA 14 VOUT VDDA pmos4 L=1.5e-05 W=1e-05 AD=8.5e-12 AS=8.5e-12 PD=1.17e-05 PS=1.17e-05 NRD=0.0425 NRS=0.0425 $X=43475 $Y=68125 $D=41
M51 VDDA 14 VOUT VDDA pmos4 L=1.5e-05 W=1e-05 AD=8.5e-12 AS=8.5e-12 PD=1.17e-05 PS=1.17e-05 NRD=0.0425 NRS=0.0425 $X=43475 $Y=89925 $D=41
M52 VDDA 14 VOUT VDDA pmos4 L=1.5e-05 W=1e-05 AD=8.5e-12 AS=8.5e-12 PD=1.17e-05 PS=1.17e-05 NRD=0.0425 NRS=0.0425 $X=43475 $Y=111725 $D=41
M53 VDDA 14 VOUT VDDA pmos4 L=1.5e-05 W=1e-05 AD=8.5e-12 AS=8.5e-12 PD=1.17e-05 PS=1.17e-05 NRD=0.0425 NRS=0.0425 $X=60775 $Y=24525 $D=41
M54 VDDA 14 VOUT VDDA pmos4 L=1.5e-05 W=1e-05 AD=8.5e-12 AS=8.5e-12 PD=1.17e-05 PS=1.17e-05 NRD=0.0425 NRS=0.0425 $X=60775 $Y=46325 $D=41
M55 VDDA 14 15 VDDA pmos4 L=1.5e-05 W=1e-05 AD=8.5e-12 AS=8.5e-12 PD=1.17e-05 PS=1.17e-05 NRD=0.0425 NRS=0.0425 $X=60775 $Y=68125 $D=41
M56 VDDA 14 VOUT VDDA pmos4 L=1.5e-05 W=1e-05 AD=8.5e-12 AS=8.5e-12 PD=1.17e-05 PS=1.17e-05 NRD=0.0425 NRS=0.0425 $X=60775 $Y=89925 $D=41
M57 VDDA 14 15 VDDA pmos4 L=1.5e-05 W=1e-05 AD=8.5e-12 AS=8.5e-12 PD=1.17e-05 PS=1.17e-05 NRD=0.0425 NRS=0.0425 $X=60775 $Y=111725 $D=41
M58 VDDA 14 VOUT VDDA pmos4 L=1.5e-05 W=1e-05 AD=8.5e-12 AS=8.5e-12 PD=1.17e-05 PS=1.17e-05 NRD=0.0425 NRS=0.0425 $X=60775 $Y=133525 $D=41
M59 VDDA 14 VOUT VDDA pmos4 L=1.5e-05 W=1e-05 AD=8.5e-12 AS=8.5e-12 PD=1.17e-05 PS=1.17e-05 NRD=0.0425 NRS=0.0425 $X=78075 $Y=24525 $D=41
M60 VDDA 14 15 VDDA pmos4 L=1.5e-05 W=1e-05 AD=8.5e-12 AS=8.5e-12 PD=1.17e-05 PS=1.17e-05 NRD=0.0425 NRS=0.0425 $X=78075 $Y=46325 $D=41
M61 VDDA 14 VOUT VDDA pmos4 L=1.5e-05 W=1e-05 AD=8.5e-12 AS=8.5e-12 PD=1.17e-05 PS=1.17e-05 NRD=0.0425 NRS=0.0425 $X=78075 $Y=68125 $D=41
M62 VDDA 14 14 VDDA pmos4 L=1.5e-05 W=1e-05 AD=8.5e-12 AS=8.5e-12 PD=1.17e-05 PS=1.17e-05 NRD=0.0425 NRS=0.0425 $X=78075 $Y=89925 $D=41
M63 VDDA 14 VOUT VDDA pmos4 L=1.5e-05 W=1e-05 AD=8.5e-12 AS=8.5e-12 PD=1.17e-05 PS=1.17e-05 NRD=0.0425 NRS=0.0425 $X=78075 $Y=111725 $D=41
M64 VDDA 14 VOUT VDDA pmos4 L=1.5e-05 W=1e-05 AD=8.5e-12 AS=8.5e-12 PD=1.17e-05 PS=1.17e-05 NRD=0.0425 NRS=0.0425 $X=78075 $Y=133525 $D=41
M65 VDDA 14 VOUT VDDA pmos4 L=1.5e-05 W=1e-05 AD=8.5e-12 AS=8.5e-12 PD=1.17e-05 PS=1.17e-05 NRD=0.0425 NRS=0.0425 $X=95375 $Y=24525 $D=41
M66 VDDA 14 VOUT VDDA pmos4 L=1.5e-05 W=1e-05 AD=8.5e-12 AS=8.5e-12 PD=1.17e-05 PS=1.17e-05 NRD=0.0425 NRS=0.0425 $X=95375 $Y=46325 $D=41
M67 VDDA 14 15 VDDA pmos4 L=1.5e-05 W=1e-05 AD=8.5e-12 AS=8.5e-12 PD=1.17e-05 PS=1.17e-05 NRD=0.0425 NRS=0.0425 $X=95375 $Y=68125 $D=41
M68 VDDA 14 VOUT VDDA pmos4 L=1.5e-05 W=1e-05 AD=8.5e-12 AS=8.5e-12 PD=1.17e-05 PS=1.17e-05 NRD=0.0425 NRS=0.0425 $X=95375 $Y=89925 $D=41
M69 VDDA 14 15 VDDA pmos4 L=1.5e-05 W=1e-05 AD=8.5e-12 AS=8.5e-12 PD=1.17e-05 PS=1.17e-05 NRD=0.0425 NRS=0.0425 $X=95375 $Y=111725 $D=41
M70 VDDA 14 VOUT VDDA pmos4 L=1.5e-05 W=1e-05 AD=8.5e-12 AS=8.5e-12 PD=1.17e-05 PS=1.17e-05 NRD=0.0425 NRS=0.0425 $X=95375 $Y=133525 $D=41
M71 VDDA 14 VOUT VDDA pmos4 L=1.5e-05 W=1e-05 AD=8.5e-12 AS=8.5e-12 PD=1.17e-05 PS=1.17e-05 NRD=0.0425 NRS=0.0425 $X=112675 $Y=24525 $D=41
M72 VDDA 14 VOUT VDDA pmos4 L=1.5e-05 W=1e-05 AD=8.5e-12 AS=8.5e-12 PD=1.17e-05 PS=1.17e-05 NRD=0.0425 NRS=0.0425 $X=112675 $Y=46325 $D=41
M73 VDDA 14 VOUT VDDA pmos4 L=1.5e-05 W=1e-05 AD=8.5e-12 AS=8.5e-12 PD=1.17e-05 PS=1.17e-05 NRD=0.0425 NRS=0.0425 $X=112675 $Y=68125 $D=41
M74 VDDA 14 VOUT VDDA pmos4 L=1.5e-05 W=1e-05 AD=8.5e-12 AS=8.5e-12 PD=1.17e-05 PS=1.17e-05 NRD=0.0425 NRS=0.0425 $X=112675 $Y=89925 $D=41
M75 VDDA 14 VOUT VDDA pmos4 L=1.5e-05 W=1e-05 AD=8.5e-12 AS=8.5e-12 PD=1.17e-05 PS=1.17e-05 NRD=0.0425 NRS=0.0425 $X=112675 $Y=111725 $D=41
M76 VDDA 14 VOUT VDDA pmos4 L=1.5e-05 W=1e-05 AD=8.5e-12 AS=8.5e-12 PD=1.17e-05 PS=1.17e-05 NRD=0.0425 NRS=0.0425 $X=112675 $Y=133525 $D=41
M77 VDDA 14 VOUT VDDA pmos4 L=1.5e-05 W=1e-05 AD=8.5e-12 AS=8.5e-12 PD=1.17e-05 PS=1.17e-05 NRD=0.0425 NRS=0.0425 $X=129975 $Y=24525 $D=41
M78 VDDA 14 VOUT VDDA pmos4 L=1.5e-05 W=1e-05 AD=8.5e-12 AS=8.5e-12 PD=1.17e-05 PS=1.17e-05 NRD=0.0425 NRS=0.0425 $X=129975 $Y=46325 $D=41
M79 VDDA 14 VOUT VDDA pmos4 L=1.5e-05 W=1e-05 AD=8.5e-12 AS=8.5e-12 PD=1.17e-05 PS=1.17e-05 NRD=0.0425 NRS=0.0425 $X=129975 $Y=68125 $D=41
M80 VDDA 14 16 VDDA pmos4 L=1.5e-05 W=1e-05 AD=8.5e-12 AS=8.5e-12 PD=1.17e-05 PS=1.17e-05 NRD=0.0425 NRS=0.0425 $X=129975 $Y=89925 $D=41
M81 VDDA 14 VOUT VDDA pmos4 L=1.5e-05 W=1e-05 AD=8.5e-12 AS=8.5e-12 PD=1.17e-05 PS=1.17e-05 NRD=0.0425 NRS=0.0425 $X=129975 $Y=111725 $D=41
M82 VDDA 14 VOUT VDDA pmos4 L=1.5e-05 W=1e-05 AD=8.5e-12 AS=8.5e-12 PD=1.17e-05 PS=1.17e-05 NRD=0.0425 NRS=0.0425 $X=129975 $Y=133525 $D=41
M83 VDDA 14 VOUT VDDA pmos4 L=1.5e-05 W=1e-05 AD=8.5e-12 AS=8.5e-12 PD=1.17e-05 PS=1.17e-05 NRD=0.0425 NRS=0.0425 $X=147275 $Y=24525 $D=41
M84 VDDA 14 VOUT VDDA pmos4 L=1.5e-05 W=1e-05 AD=8.5e-12 AS=8.5e-12 PD=1.17e-05 PS=1.17e-05 NRD=0.0425 NRS=0.0425 $X=147275 $Y=46325 $D=41
M85 VDDA 14 VOUT VDDA pmos4 L=1.5e-05 W=1e-05 AD=8.5e-12 AS=8.5e-12 PD=1.17e-05 PS=1.17e-05 NRD=0.0425 NRS=0.0425 $X=147275 $Y=68125 $D=41
M86 VDDA 14 VOUT VDDA pmos4 L=1.5e-05 W=1e-05 AD=8.5e-12 AS=8.5e-12 PD=1.17e-05 PS=1.17e-05 NRD=0.0425 NRS=0.0425 $X=147275 $Y=89925 $D=41
M87 VDDA 14 VOUT VDDA pmos4 L=1.5e-05 W=1e-05 AD=8.5e-12 AS=8.5e-12 PD=1.17e-05 PS=1.17e-05 NRD=0.0425 NRS=0.0425 $X=147275 $Y=111725 $D=41
M88 VDDA 14 VOUT VDDA pmos4 L=1.5e-05 W=1e-05 AD=8.5e-12 AS=8.5e-12 PD=1.17e-05 PS=1.17e-05 NRD=0.0425 NRS=0.0425 $X=147275 $Y=133525 $D=41
M89 VDDA 14 VOUT VDDA pmos4 L=1.5e-05 W=1e-05 AD=8.5e-12 AS=8.5e-12 PD=1.17e-05 PS=1.17e-05 NRD=0.0425 NRS=0.0425 $X=164575 $Y=24525 $D=41
M90 VDDA 14 15 VDDA pmos4 L=1.5e-05 W=1e-05 AD=8.5e-12 AS=8.5e-12 PD=1.17e-05 PS=1.17e-05 NRD=0.0425 NRS=0.0425 $X=164575 $Y=46325 $D=41
M91 VDDA 14 VOUT VDDA pmos4 L=1.5e-05 W=1e-05 AD=8.5e-12 AS=8.5e-12 PD=1.17e-05 PS=1.17e-05 NRD=0.0425 NRS=0.0425 $X=164575 $Y=68125 $D=41
M92 VDDA 14 15 VDDA pmos4 L=1.5e-05 W=1e-05 AD=8.5e-12 AS=8.5e-12 PD=1.17e-05 PS=1.17e-05 NRD=0.0425 NRS=0.0425 $X=164575 $Y=89925 $D=41
M93 VDDA 14 VOUT VDDA pmos4 L=1.5e-05 W=1e-05 AD=8.5e-12 AS=8.5e-12 PD=1.17e-05 PS=1.17e-05 NRD=0.0425 NRS=0.0425 $X=164575 $Y=111725 $D=41
M94 VDDA 14 VOUT VDDA pmos4 L=1.5e-05 W=1e-05 AD=8.5e-12 AS=8.5e-12 PD=1.17e-05 PS=1.17e-05 NRD=0.0425 NRS=0.0425 $X=164575 $Y=133525 $D=41
M95 VDDA 14 VOUT VDDA pmos4 L=1.5e-05 W=1e-05 AD=8.5e-12 AS=8.5e-12 PD=1.17e-05 PS=1.17e-05 NRD=0.0425 NRS=0.0425 $X=181875 $Y=24525 $D=41
M96 VDDA 14 VOUT VDDA pmos4 L=1.5e-05 W=1e-05 AD=8.5e-12 AS=8.5e-12 PD=1.17e-05 PS=1.17e-05 NRD=0.0425 NRS=0.0425 $X=181875 $Y=46325 $D=41
M97 VDDA 14 14 VDDA pmos4 L=1.5e-05 W=1e-05 AD=8.5e-12 AS=8.5e-12 PD=1.17e-05 PS=1.17e-05 NRD=0.0425 NRS=0.0425 $X=181875 $Y=68125 $D=41
M98 VDDA 14 VOUT VDDA pmos4 L=1.5e-05 W=1e-05 AD=8.5e-12 AS=8.5e-12 PD=1.17e-05 PS=1.17e-05 NRD=0.0425 NRS=0.0425 $X=181875 $Y=89925 $D=41
M99 VDDA 14 15 VDDA pmos4 L=1.5e-05 W=1e-05 AD=8.5e-12 AS=8.5e-12 PD=1.17e-05 PS=1.17e-05 NRD=0.0425 NRS=0.0425 $X=181875 $Y=111725 $D=41
M100 VDDA 14 VOUT VDDA pmos4 L=1.5e-05 W=1e-05 AD=8.5e-12 AS=8.5e-12 PD=1.17e-05 PS=1.17e-05 NRD=0.0425 NRS=0.0425 $X=181875 $Y=133525 $D=41
M101 VDDA 14 VOUT VDDA pmos4 L=1.5e-05 W=1e-05 AD=8.5e-12 AS=8.5e-12 PD=1.17e-05 PS=1.17e-05 NRD=0.0425 NRS=0.0425 $X=199175 $Y=24525 $D=41
M102 VDDA 14 15 VDDA pmos4 L=1.5e-05 W=1e-05 AD=8.5e-12 AS=8.5e-12 PD=1.17e-05 PS=1.17e-05 NRD=0.0425 NRS=0.0425 $X=199175 $Y=46325 $D=41
M103 VDDA 14 VOUT VDDA pmos4 L=1.5e-05 W=1e-05 AD=8.5e-12 AS=8.5e-12 PD=1.17e-05 PS=1.17e-05 NRD=0.0425 NRS=0.0425 $X=199175 $Y=68125 $D=41
M104 VDDA 14 15 VDDA pmos4 L=1.5e-05 W=1e-05 AD=8.5e-12 AS=8.5e-12 PD=1.17e-05 PS=1.17e-05 NRD=0.0425 NRS=0.0425 $X=199175 $Y=89925 $D=41
M105 VDDA 14 VOUT VDDA pmos4 L=1.5e-05 W=1e-05 AD=8.5e-12 AS=8.5e-12 PD=1.17e-05 PS=1.17e-05 NRD=0.0425 NRS=0.0425 $X=199175 $Y=111725 $D=41
M106 VDDA 14 VOUT VDDA pmos4 L=1.5e-05 W=1e-05 AD=8.5e-12 AS=8.5e-12 PD=1.17e-05 PS=1.17e-05 NRD=0.0425 NRS=0.0425 $X=199175 $Y=133525 $D=41
M107 VDDA 14 VOUT VDDA pmos4 L=1.5e-05 W=1e-05 AD=8.5e-12 AS=8.5e-12 PD=1.17e-05 PS=1.17e-05 NRD=0.0425 NRS=0.0425 $X=216475 $Y=24525 $D=41
M108 VDDA 14 VOUT VDDA pmos4 L=1.5e-05 W=1e-05 AD=8.5e-12 AS=8.5e-12 PD=1.17e-05 PS=1.17e-05 NRD=0.0425 NRS=0.0425 $X=216475 $Y=46325 $D=41
M109 VDDA 14 VOUT VDDA pmos4 L=1.5e-05 W=1e-05 AD=8.5e-12 AS=8.5e-12 PD=1.17e-05 PS=1.17e-05 NRD=0.0425 NRS=0.0425 $X=216475 $Y=68125 $D=41
M110 VDDA 14 VOUT VDDA pmos4 L=1.5e-05 W=1e-05 AD=8.5e-12 AS=8.5e-12 PD=1.17e-05 PS=1.17e-05 NRD=0.0425 NRS=0.0425 $X=216475 $Y=89925 $D=41
M111 VDDA 14 VOUT VDDA pmos4 L=1.5e-05 W=1e-05 AD=8.5e-12 AS=8.5e-12 PD=1.17e-05 PS=1.17e-05 NRD=0.0425 NRS=0.0425 $X=216475 $Y=111725 $D=41
M112 15 VIN 17 15 pmos4 L=4e-06 W=1e-05 AD=8.5e-12 AS=8.5e-12 PD=1.17e-05 PS=1.17e-05 NRD=0.0425 NRS=0.0425 $X=316075 $Y=139900 $D=41
M113 15 9 3 15 pmos4 L=4e-06 W=1e-05 AD=8.5e-12 AS=8.5e-12 PD=1.17e-05 PS=1.17e-05 NRD=0.0425 NRS=0.0425 $X=316075 $Y=156700 $D=41
M114 15 9 3 15 pmos4 L=4e-06 W=1e-05 AD=8.5e-12 AS=8.5e-12 PD=1.17e-05 PS=1.17e-05 NRD=0.0425 NRS=0.0425 $X=322375 $Y=139900 $D=41
M115 15 VIN 17 15 pmos4 L=4e-06 W=1e-05 AD=8.5e-12 AS=8.5e-12 PD=1.17e-05 PS=1.17e-05 NRD=0.0425 NRS=0.0425 $X=322375 $Y=156700 $D=41
M116 15 9 3 15 pmos4 L=4e-06 W=1e-05 AD=8.5e-12 AS=8.5e-12 PD=1.17e-05 PS=1.17e-05 NRD=0.0425 NRS=0.0425 $X=341275 $Y=139900 $D=41
M117 15 VIN 17 15 pmos4 L=4e-06 W=1e-05 AD=8.5e-12 AS=8.5e-12 PD=1.17e-05 PS=1.17e-05 NRD=0.0425 NRS=0.0425 $X=341275 $Y=156700 $D=41
M118 15 VIN 17 15 pmos4 L=4e-06 W=1e-05 AD=8.5e-12 AS=8.5e-12 PD=1.17e-05 PS=1.17e-05 NRD=0.0425 NRS=0.0425 $X=347575 $Y=139900 $D=41
M119 15 9 3 15 pmos4 L=4e-06 W=1e-05 AD=8.5e-12 AS=8.5e-12 PD=1.17e-05 PS=1.17e-05 NRD=0.0425 NRS=0.0425 $X=347575 $Y=156700 $D=41
C120 GNDA IBIAS $[cpolya] $A=341.145 $P=73.9 $X=357900 $Y=-4900 $D=58
X121 GNDA VOUT 17 GNDA nmos4_CDNS_7807366010386 $T=404250 34950 0 90 $X=395300 $Y=34550
X147 VDDA ICV_60 $T=42025 2725 0 90 $X=24125 $Y=1525
X148 VDDA ICV_60 $T=42025 24525 0 90 $X=24125 $Y=23325
X149 VDDA ICV_60 $T=42025 46325 0 90 $X=24125 $Y=45125
X150 VDDA ICV_60 $T=42025 68125 0 90 $X=24125 $Y=66925
X151 VDDA ICV_60 $T=42025 89925 0 90 $X=24125 $Y=88725
X152 VDDA ICV_60 $T=42025 111725 0 90 $X=24125 $Y=110525
X153 VDDA ICV_60 $T=42025 133525 0 90 $X=24125 $Y=132325
X154 VDDA ICV_60 $T=42025 155325 0 90 $X=24125 $Y=154125
X157 GNDA 18 19 nmos4_CDNS_7807366010370 $T=312200 14450 0 90 $X=298250 $Y=14050
X158 GNDA 19 19 nmos4_CDNS_7807366010370 $T=312200 29250 0 90 $X=298250 $Y=28850
X159 GNDA 19 19 nmos4_CDNS_7807366010370 $T=326500 14450 0 90 $X=312550 $Y=14050
X160 GNDA 18 19 nmos4_CDNS_7807366010370 $T=326500 29250 0 90 $X=312550 $Y=28850
X161 16 GNDA pmos4_CDNS_7807366010365 $T=384825 56825 0 90 $X=369425 $Y=55625
X162 9 CVGA rpolyhc_CDNS_7807366010363 $T=469750 33350 0 180 $X=420250 $Y=12400
X163 20 9 rpolyhc_CDNS_7807366010363 $T=425600 52950 1 0 $X=420250 $Y=32000
X164 23 20 rpolyhc_CDNS_7807366010363 $T=469750 72550 0 180 $X=420250 $Y=51600
X165 21 23 rpolyhc_CDNS_7807366010363 $T=425600 92150 1 0 $X=420250 $Y=71200
X166 22 25 rpolyhc_CDNS_7807366010363 $T=474450 17050 0 0 $X=469100 $Y=12400
X167 25 24 rpolyhc_CDNS_7807366010363 $T=518600 36650 1 180 $X=469100 $Y=32000
X168 24 26 rpolyhc_CDNS_7807366010363 $T=474450 56250 0 0 $X=469100 $Y=51600
X169 26 21 rpolyhc_CDNS_7807366010363 $T=518600 75850 1 180 $X=469100 $Y=71200
X170 29 22 rpolyhc_CDNS_7807366010363 $T=567450 33350 0 180 $X=517950 $Y=12400
X171 27 29 rpolyhc_CDNS_7807366010363 $T=523300 52950 1 0 $X=517950 $Y=32000
X172 30 27 rpolyhc_CDNS_7807366010363 $T=567450 72550 0 180 $X=517950 $Y=51600
X173 32 30 rpolyhc_CDNS_7807366010363 $T=523300 92150 1 0 $X=517950 $Y=71200
X174 VOUT 34 rpolyhc_CDNS_7807366010363 $T=572150 17050 0 0 $X=566800 $Y=12400
X175 34 31 rpolyhc_CDNS_7807366010363 $T=616300 36650 1 180 $X=566800 $Y=32000
X176 31 35 rpolyhc_CDNS_7807366010363 $T=572150 56250 0 0 $X=566800 $Y=51600
X177 35 32 rpolyhc_CDNS_7807366010363 $T=616300 75850 1 180 $X=566800 $Y=71200
X178 GNDA VDDA cpolyc_CDNS_7807366010361 $T=618350 134800 1 180 $X=564200 $Y=133450
X268 19 IBIAS IBIAS GNDA nmos4_CDNS_78073660103165 $T=318325 60350 0 90 $X=281375 $Y=59950
X269 18 14 IBIAS GNDA nmos4_CDNS_78073660103165 $T=355625 60350 0 90 $X=318675 $Y=59950
X276 15 3 17 9 VIN ICV_57 $T=302025 139900 0 90 $X=295125 $Y=138700
X277 15 17 3 VIN 9 ICV_57 $T=302025 156700 0 90 $X=295125 $Y=155500
X278 15 17 17 VIN VIN ICV_57 $T=327225 139900 0 90 $X=320325 $Y=138700
X279 15 3 3 9 9 ICV_57 $T=327225 156700 0 90 $X=320325 $Y=155500
X280 15 17 3 VIN 9 ICV_57 $T=352425 139900 0 90 $X=345525 $Y=138700
X281 15 3 17 9 VIN ICV_57 $T=352425 156700 0 90 $X=345525 $Y=155500
X284 9 S<0> 20 GNDA VDDA mux21 $T=414650 -9800 0 0 $X=415000 $Y=-9450
X285 20 S<1> 21 GNDA VDDA mux21 $T=454675 -9800 0 0 $X=455025 $Y=-9450
X286 21 S<2> 22 GNDA VDDA mux21 $T=505525 -9800 0 0 $X=505875 $Y=-9450
X287 22 S<3> VOUT GNDA VDDA mux21 $T=554425 -9800 0 0 $X=554775 $Y=-9450
X288 VOUT 12 cpolyc_CDNS_78073660103167 $T=431875 102700 0 0 $X=430525 $Y=101350
X289 VOUT 12 cpolyc_CDNS_78073660103167 $T=431875 143100 0 0 $X=430525 $Y=141750
X290 VOUT 12 cpolyc_CDNS_78073660103167 $T=473825 102700 0 0 $X=472475 $Y=101350
X291 VOUT 12 cpolyc_CDNS_78073660103167 $T=473825 143100 0 0 $X=472475 $Y=141750
X292 VOUT 12 cpolyc_CDNS_78073660103167 $T=515775 102700 0 0 $X=514425 $Y=101350
X293 VOUT 12 cpolyc_CDNS_78073660103167 $T=515775 143100 0 0 $X=514425 $Y=141750
X294 28 rpolyhc_CDNS_78073660103166 $T=561100 106350 0 0 $X=557100 $Y=102900
X295 33 rpolyhc_CDNS_78073660103166 $T=586700 125400 0 0 $X=582700 $Y=121950
.ENDS
***************************************
.SUBCKT cpolyc_CDNS_78073660103138 2 3
** N=3 EP=2 IP=0 FDC=1
C0 2 3 $[cpolya] $A=6942.87 $P=333.3 $X=1800 $Y=1000 $D=58
.ENDS
***************************************
.SUBCKT rpolyhc_CDNS_78073660103136 1 2
** N=3 EP=2 IP=0 FDC=1
R0 1 2 L=0.00025 W=8e-07 $[rpolyh] $X=-800 $Y=1550 $D=18
.ENDS
***************************************
.SUBCKT ICV_53 1 2 3
*.CALIBRE ICV_CELL 9
** N=4 EP=3 IP=6 FDC=2
X0 1 2 rpolyhc_CDNS_78073660103136 $T=0 0 0 0 $X=-6000 $Y=-4650
X1 2 3 rpolyhc_CDNS_78073660103136 $T=49000 10300 1 180 $X=-6000 $Y=5650
.ENDS
***************************************
.SUBCKT pmos4_CDNS_78073660103142
** N=5 EP=0 IP=0 FDC=0
.ENDS
***************************************
.SUBCKT ICV_51
** N=8 EP=0 IP=10 FDC=0
.ENDS
***************************************
.SUBCKT ICV_52 3 4 5 9 10 13
** N=13 EP=6 IP=16 FDC=2
M0 4 9 3 13 pmos4 L=2e-06 W=1e-05 AD=8.5e-12 AS=8.5e-12 PD=1.17e-05 PS=1.17e-05 NRD=0.0425 NRS=0.0425 $X=0 $Y=-7750 $D=41
M1 5 10 3 13 pmos4 L=2e-06 W=1e-05 AD=8.5e-12 AS=8.5e-12 PD=1.17e-05 PS=1.17e-05 NRD=0.0425 NRS=0.0425 $X=0 $Y=-3450 $D=41
.ENDS
***************************************
.SUBCKT ICV_54 1 2 3 4 5 6
** N=7 EP=6 IP=26 FDC=8
M0 4 4 4 4 pmos4 L=2e-06 W=1e-05 AD=8.5e-12 AS=8.5e-12 PD=1.17e-05 PS=1.17e-05 NRD=0.0425 NRS=0.0425 $X=0 $Y=850 $D=42
M1 2 5 1 4 pmos4 L=2e-06 W=1e-05 AD=8.5e-12 AS=8.5e-12 PD=1.17e-05 PS=1.17e-05 NRD=0.0425 NRS=0.0425 $X=0 $Y=-29250 $D=41
M2 2 5 1 4 pmos4 L=2e-06 W=1e-05 AD=8.5e-12 AS=8.5e-12 PD=1.17e-05 PS=1.17e-05 NRD=0.0425 NRS=0.0425 $X=0 $Y=-16350 $D=41
M3 3 6 1 4 pmos4 L=2e-06 W=1e-05 AD=8.5e-12 AS=8.5e-12 PD=1.17e-05 PS=1.17e-05 NRD=0.0425 NRS=0.0425 $X=0 $Y=-12050 $D=41
X4 1 3 3 6 6 4 ICV_52 $T=0 -17200 0 0 $X=-1200 $Y=-31300
X5 1 2 3 5 6 4 ICV_52 $T=0 0 0 0 $X=-1200 $Y=-14100
.ENDS
***************************************
.SUBCKT nmos4_CDNS_78073660103140 1 2 3
** N=3 EP=3 IP=0 FDC=1
M0 2 3 1 1 nmos4 L=4e-06 W=1e-05 AD=8.5e-12 AS=8.5e-12 PD=1.17e-05 PS=1.17e-05 NRD=0.0425 NRS=0.0425 $X=0 $Y=850 $D=37
.ENDS
***************************************
.SUBCKT nmos4_CDNS_78073660103141 1 2 3
** N=3 EP=3 IP=0 FDC=1
M0 2 3 1 1 nmos4 L=1e-05 W=2e-05 AD=1.7e-11 AS=1.7e-11 PD=2.17e-05 PS=2.17e-05 NRD=0.02125 NRS=0.02125 $X=0 $Y=850 $D=37
.ENDS
***************************************
.SUBCKT P1_C_CDNS_78073660103491
** N=2 EP=0 IP=0 FDC=0
.ENDS
***************************************
.SUBCKT ICV_47
** N=6 EP=0 IP=10 FDC=0
.ENDS
***************************************
.SUBCKT ICV_48
** N=9 EP=0 IP=12 FDC=0
.ENDS
***************************************
.SUBCKT ICV_49
** N=11 EP=0 IP=18 FDC=0
.ENDS
***************************************
.SUBCKT ICV_50 1
** N=7 EP=1 IP=22 FDC=2
M0 1 1 1 1 pmos4 L=5e-06 W=5e-06 AD=4.25e-12 AS=4.25e-12 PD=6.7e-06 PS=6.7e-06 NRD=0.085 NRS=0.085 $X=0 $Y=-108650 $D=42
M1 1 1 1 1 pmos4 L=5e-06 W=5e-06 AD=4.25e-12 AS=4.25e-12 PD=6.7e-06 PS=6.7e-06 NRD=0.085 NRS=0.085 $X=0 $Y=850 $D=42
.ENDS
***************************************
.SUBCKT P1_C_CDNS_78073660103487
** N=2 EP=0 IP=0 FDC=0
.ENDS
***************************************
.SUBCKT BUFFER VDDA VOUT VIN CBUF IBIAS GNDA
** N=18 EP=6 IP=252 FDC=215
R0 8 10 L=5.9e-06 W=1.2e-06 $[rpolyh] $X=159175 $Y=120350 $D=18
D1 GNDA GNDA p_nwd AREA=7231.65 PJ=371.6 $X=15875 $Y=79950 $D=87
D2 GNDA VDDA p_nwd AREA=4503.05 PJ=272.4 $X=53300 $Y=20450 $D=87
D3 GNDA GNDA p_nwd AREA=557.75 PJ=94.5 $X=147475 $Y=110700 $D=87
D4 GNDA VDDA p_nwd AREA=26054.2 PJ=646.6 $X=201525 $Y=54700 $D=87
M5 VOUT 8 GNDA GNDA nmos4 L=3.5e-07 W=5e-06 AD=2.5e-12 AS=4.25e-12 PD=1e-06 PS=6.7e-06 NRD=0.085 NRS=0.085 $X=157475 $Y=80525 $D=37
M6 GNDA 8 VOUT GNDA nmos4 L=3.5e-07 W=5e-06 AD=2.5e-12 AS=2.5e-12 PD=1e-06 PS=1e-06 NRD=0.085 NRS=0.085 $X=158825 $Y=80525 $D=37
M7 VOUT 8 GNDA GNDA nmos4 L=3.5e-07 W=5e-06 AD=2.5e-12 AS=2.5e-12 PD=1e-06 PS=1e-06 NRD=0.085 NRS=0.085 $X=160175 $Y=80525 $D=37
M8 GNDA 8 VOUT GNDA nmos4 L=3.5e-07 W=5e-06 AD=2.5e-12 AS=2.5e-12 PD=1e-06 PS=1e-06 NRD=0.085 NRS=0.085 $X=161525 $Y=80525 $D=37
M9 VOUT 8 GNDA GNDA nmos4 L=3.5e-07 W=5e-06 AD=2.5e-12 AS=2.5e-12 PD=1e-06 PS=1e-06 NRD=0.085 NRS=0.085 $X=162875 $Y=80525 $D=37
M10 GNDA 8 VOUT GNDA nmos4 L=3.5e-07 W=5e-06 AD=2.5e-12 AS=2.5e-12 PD=1e-06 PS=1e-06 NRD=0.085 NRS=0.085 $X=164225 $Y=80525 $D=37
M11 VOUT 8 GNDA GNDA nmos4 L=3.5e-07 W=5e-06 AD=2.5e-12 AS=2.5e-12 PD=1e-06 PS=1e-06 NRD=0.085 NRS=0.085 $X=165575 $Y=80525 $D=37
M12 GNDA 8 VOUT GNDA nmos4 L=3.5e-07 W=5e-06 AD=2.5e-12 AS=2.5e-12 PD=1e-06 PS=1e-06 NRD=0.085 NRS=0.085 $X=166925 $Y=80525 $D=37
M13 VOUT 8 GNDA GNDA nmos4 L=3.5e-07 W=5e-06 AD=2.5e-12 AS=2.5e-12 PD=1e-06 PS=1e-06 NRD=0.085 NRS=0.085 $X=168275 $Y=80525 $D=37
M14 GNDA 8 VOUT GNDA nmos4 L=3.5e-07 W=5e-06 AD=4.25e-12 AS=2.5e-12 PD=6.7e-06 PS=1e-06 NRD=0.085 NRS=0.085 $X=169625 $Y=80525 $D=37
M15 VDDA VDDA VDDA VDDA pmos4 L=2e-06 W=1e-05 AD=8.5e-12 AS=8.5e-12 PD=1.17e-05 PS=1.17e-05 NRD=0.0425 NRS=0.0425 $X=115800 $Y=34800 $D=42
M16 VDDA VDDA VDDA VDDA pmos4 L=2e-06 W=1e-05 AD=8.5e-12 AS=8.5e-12 PD=1.17e-05 PS=1.17e-05 NRD=0.0425 NRS=0.0425 $X=115800 $Y=52600 $D=42
M17 VDDA VDDA VDDA VDDA pmos4 L=5e-06 W=5e-06 AD=4.25e-12 AS=4.25e-12 PD=6.7e-06 PS=6.7e-06 NRD=0.085 NRS=0.085 $X=228025 $Y=73050 $D=42
M18 VDDA VDDA VDDA VDDA pmos4 L=5e-06 W=5e-06 AD=4.25e-12 AS=4.25e-12 PD=6.7e-06 PS=6.7e-06 NRD=0.085 NRS=0.085 $X=228025 $Y=201750 $D=42
M19 VDDA VDDA VDDA VDDA pmos4 L=5e-06 W=5e-06 AD=4.25e-12 AS=4.25e-12 PD=6.7e-06 PS=6.7e-06 NRD=0.085 NRS=0.085 $X=235325 $Y=73050 $D=42
M20 VDDA VDDA VDDA VDDA pmos4 L=5e-06 W=5e-06 AD=4.25e-12 AS=4.25e-12 PD=6.7e-06 PS=6.7e-06 NRD=0.085 NRS=0.085 $X=235325 $Y=201750 $D=42
M21 VDDA VDDA VDDA VDDA pmos4 L=5e-06 W=5e-06 AD=4.25e-12 AS=4.25e-12 PD=6.7e-06 PS=6.7e-06 NRD=0.085 NRS=0.085 $X=242625 $Y=73050 $D=42
M22 VDDA VDDA VDDA VDDA pmos4 L=5e-06 W=5e-06 AD=4.25e-12 AS=4.25e-12 PD=6.7e-06 PS=6.7e-06 NRD=0.085 NRS=0.085 $X=242625 $Y=201750 $D=42
M23 VDDA VDDA VDDA VDDA pmos4 L=5e-06 W=5e-06 AD=4.25e-12 AS=4.25e-12 PD=6.7e-06 PS=6.7e-06 NRD=0.085 NRS=0.085 $X=249925 $Y=73050 $D=42
M24 VDDA VDDA VDDA VDDA pmos4 L=5e-06 W=5e-06 AD=4.25e-12 AS=4.25e-12 PD=6.7e-06 PS=6.7e-06 NRD=0.085 NRS=0.085 $X=249925 $Y=201750 $D=42
M25 VDDA VDDA VDDA VDDA pmos4 L=5e-06 W=5e-06 AD=4.25e-12 AS=4.25e-12 PD=6.7e-06 PS=6.7e-06 NRD=0.085 NRS=0.085 $X=257225 $Y=73050 $D=42
M26 VDDA VDDA VDDA VDDA pmos4 L=5e-06 W=5e-06 AD=4.25e-12 AS=4.25e-12 PD=6.7e-06 PS=6.7e-06 NRD=0.085 NRS=0.085 $X=257225 $Y=201750 $D=42
M27 VDDA VDDA VDDA VDDA pmos4 L=5e-06 W=5e-06 AD=4.25e-12 AS=4.25e-12 PD=6.7e-06 PS=6.7e-06 NRD=0.085 NRS=0.085 $X=264525 $Y=73050 $D=42
M28 VDDA VDDA VDDA VDDA pmos4 L=5e-06 W=5e-06 AD=4.25e-12 AS=4.25e-12 PD=6.7e-06 PS=6.7e-06 NRD=0.085 NRS=0.085 $X=264525 $Y=201750 $D=42
M29 VDDA VDDA VDDA VDDA pmos4 L=5e-06 W=5e-06 AD=4.25e-12 AS=4.25e-12 PD=6.7e-06 PS=6.7e-06 NRD=0.085 NRS=0.085 $X=271825 $Y=73050 $D=42
M30 VDDA VDDA VDDA VDDA pmos4 L=5e-06 W=5e-06 AD=4.25e-12 AS=4.25e-12 PD=6.7e-06 PS=6.7e-06 NRD=0.085 NRS=0.085 $X=271825 $Y=201750 $D=42
M31 VDDA VDDA VDDA VDDA pmos4 L=5e-06 W=5e-06 AD=4.25e-12 AS=4.25e-12 PD=6.7e-06 PS=6.7e-06 NRD=0.085 NRS=0.085 $X=279125 $Y=73050 $D=42
M32 VDDA VDDA VDDA VDDA pmos4 L=5e-06 W=5e-06 AD=4.25e-12 AS=4.25e-12 PD=6.7e-06 PS=6.7e-06 NRD=0.085 NRS=0.085 $X=279125 $Y=201750 $D=42
M33 VDDA VDDA VDDA VDDA pmos4 L=5e-06 W=5e-06 AD=4.25e-12 AS=4.25e-12 PD=6.7e-06 PS=6.7e-06 NRD=0.085 NRS=0.085 $X=286425 $Y=73050 $D=42
M34 VDDA VDDA VDDA VDDA pmos4 L=5e-06 W=5e-06 AD=4.25e-12 AS=4.25e-12 PD=6.7e-06 PS=6.7e-06 NRD=0.085 NRS=0.085 $X=286425 $Y=201750 $D=42
M35 VDDA VDDA VDDA VDDA pmos4 L=5e-06 W=5e-06 AD=4.25e-12 AS=4.25e-12 PD=6.7e-06 PS=6.7e-06 NRD=0.085 NRS=0.085 $X=293725 $Y=73050 $D=42
M36 VDDA VDDA VDDA VDDA pmos4 L=5e-06 W=5e-06 AD=4.25e-12 AS=4.25e-12 PD=6.7e-06 PS=6.7e-06 NRD=0.085 NRS=0.085 $X=293725 $Y=201750 $D=42
M37 VDDA VDDA VDDA VDDA pmos4 L=5e-06 W=5e-06 AD=4.25e-12 AS=4.25e-12 PD=6.7e-06 PS=6.7e-06 NRD=0.085 NRS=0.085 $X=301025 $Y=73050 $D=42
M38 VDDA VDDA VDDA VDDA pmos4 L=5e-06 W=5e-06 AD=4.25e-12 AS=4.25e-12 PD=6.7e-06 PS=6.7e-06 NRD=0.085 NRS=0.085 $X=301025 $Y=201750 $D=42
M39 VDDA VDDA VDDA VDDA pmos4 L=5e-06 W=5e-06 AD=4.25e-12 AS=4.25e-12 PD=6.7e-06 PS=6.7e-06 NRD=0.085 NRS=0.085 $X=308325 $Y=73050 $D=42
M40 VDDA VDDA VDDA VDDA pmos4 L=5e-06 W=5e-06 AD=4.25e-12 AS=4.25e-12 PD=6.7e-06 PS=6.7e-06 NRD=0.085 NRS=0.085 $X=308325 $Y=201750 $D=42
M41 VDDA VDDA VDDA VDDA pmos4 L=5e-06 W=5e-06 AD=4.25e-12 AS=4.25e-12 PD=6.7e-06 PS=6.7e-06 NRD=0.085 NRS=0.085 $X=315625 $Y=73050 $D=42
M42 VDDA VDDA VDDA VDDA pmos4 L=5e-06 W=5e-06 AD=4.25e-12 AS=4.25e-12 PD=6.7e-06 PS=6.7e-06 NRD=0.085 NRS=0.085 $X=315625 $Y=201750 $D=42
M43 VDDA VDDA VDDA VDDA pmos4 L=5e-06 W=5e-06 AD=4.25e-12 AS=4.25e-12 PD=6.7e-06 PS=6.7e-06 NRD=0.085 NRS=0.085 $X=322925 $Y=73050 $D=42
M44 VDDA VDDA VDDA VDDA pmos4 L=5e-06 W=5e-06 AD=4.25e-12 AS=4.25e-12 PD=6.7e-06 PS=6.7e-06 NRD=0.085 NRS=0.085 $X=322925 $Y=201750 $D=42
M45 9 12 7 VDDA pmos4 L=2e-06 W=1e-05 AD=8.5e-12 AS=8.5e-12 PD=1.17e-05 PS=1.17e-05 NRD=0.0425 NRS=0.0425 $X=102900 $Y=34800 $D=41
M46 9 VIN 8 VDDA pmos4 L=2e-06 W=1e-05 AD=8.5e-12 AS=8.5e-12 PD=1.17e-05 PS=1.17e-05 NRD=0.0425 NRS=0.0425 $X=102900 $Y=52600 $D=41
M47 VDDA 11 VOUT VDDA pmos4 L=5e-06 W=5e-06 AD=4.25e-12 AS=4.25e-12 PD=6.7e-06 PS=6.7e-06 NRD=0.085 NRS=0.085 $X=228025 $Y=87350 $D=41
M48 VDDA 11 VOUT VDDA pmos4 L=5e-06 W=5e-06 AD=4.25e-12 AS=4.25e-12 PD=6.7e-06 PS=6.7e-06 NRD=0.085 NRS=0.085 $X=228025 $Y=101650 $D=41
M49 VDDA 11 VOUT VDDA pmos4 L=5e-06 W=5e-06 AD=4.25e-12 AS=4.25e-12 PD=6.7e-06 PS=6.7e-06 NRD=0.085 NRS=0.085 $X=228025 $Y=115950 $D=41
M50 VDDA 11 9 VDDA pmos4 L=5e-06 W=5e-06 AD=4.25e-12 AS=4.25e-12 PD=6.7e-06 PS=6.7e-06 NRD=0.085 NRS=0.085 $X=228025 $Y=130250 $D=41
M51 VDDA 11 11 VDDA pmos4 L=5e-06 W=5e-06 AD=4.25e-12 AS=4.25e-12 PD=6.7e-06 PS=6.7e-06 NRD=0.085 NRS=0.085 $X=228025 $Y=144550 $D=41
M52 VDDA 11 VOUT VDDA pmos4 L=5e-06 W=5e-06 AD=4.25e-12 AS=4.25e-12 PD=6.7e-06 PS=6.7e-06 NRD=0.085 NRS=0.085 $X=228025 $Y=158850 $D=41
M53 VDDA 11 VOUT VDDA pmos4 L=5e-06 W=5e-06 AD=4.25e-12 AS=4.25e-12 PD=6.7e-06 PS=6.7e-06 NRD=0.085 NRS=0.085 $X=228025 $Y=173150 $D=41
M54 VDDA 11 VOUT VDDA pmos4 L=5e-06 W=5e-06 AD=4.25e-12 AS=4.25e-12 PD=6.7e-06 PS=6.7e-06 NRD=0.085 NRS=0.085 $X=228025 $Y=187450 $D=41
M55 VDDA 11 VOUT VDDA pmos4 L=5e-06 W=5e-06 AD=4.25e-12 AS=4.25e-12 PD=6.7e-06 PS=6.7e-06 NRD=0.085 NRS=0.085 $X=235325 $Y=87350 $D=41
M56 VDDA 11 VOUT VDDA pmos4 L=5e-06 W=5e-06 AD=4.25e-12 AS=4.25e-12 PD=6.7e-06 PS=6.7e-06 NRD=0.085 NRS=0.085 $X=235325 $Y=101650 $D=41
M57 VDDA 11 VOUT VDDA pmos4 L=5e-06 W=5e-06 AD=4.25e-12 AS=4.25e-12 PD=6.7e-06 PS=6.7e-06 NRD=0.085 NRS=0.085 $X=235325 $Y=115950 $D=41
M58 VDDA 11 9 VDDA pmos4 L=5e-06 W=5e-06 AD=4.25e-12 AS=4.25e-12 PD=6.7e-06 PS=6.7e-06 NRD=0.085 NRS=0.085 $X=235325 $Y=130250 $D=41
M59 VDDA 11 9 VDDA pmos4 L=5e-06 W=5e-06 AD=4.25e-12 AS=4.25e-12 PD=6.7e-06 PS=6.7e-06 NRD=0.085 NRS=0.085 $X=235325 $Y=144550 $D=41
M60 VDDA 11 VOUT VDDA pmos4 L=5e-06 W=5e-06 AD=4.25e-12 AS=4.25e-12 PD=6.7e-06 PS=6.7e-06 NRD=0.085 NRS=0.085 $X=235325 $Y=158850 $D=41
M61 VDDA 11 VOUT VDDA pmos4 L=5e-06 W=5e-06 AD=4.25e-12 AS=4.25e-12 PD=6.7e-06 PS=6.7e-06 NRD=0.085 NRS=0.085 $X=235325 $Y=173150 $D=41
M62 VDDA 11 VOUT VDDA pmos4 L=5e-06 W=5e-06 AD=4.25e-12 AS=4.25e-12 PD=6.7e-06 PS=6.7e-06 NRD=0.085 NRS=0.085 $X=235325 $Y=187450 $D=41
M63 VDDA 11 VOUT VDDA pmos4 L=5e-06 W=5e-06 AD=4.25e-12 AS=4.25e-12 PD=6.7e-06 PS=6.7e-06 NRD=0.085 NRS=0.085 $X=242625 $Y=87350 $D=41
M64 VDDA 11 VOUT VDDA pmos4 L=5e-06 W=5e-06 AD=4.25e-12 AS=4.25e-12 PD=6.7e-06 PS=6.7e-06 NRD=0.085 NRS=0.085 $X=242625 $Y=101650 $D=41
M65 VDDA 11 VOUT VDDA pmos4 L=5e-06 W=5e-06 AD=4.25e-12 AS=4.25e-12 PD=6.7e-06 PS=6.7e-06 NRD=0.085 NRS=0.085 $X=242625 $Y=115950 $D=41
M66 VDDA 11 9 VDDA pmos4 L=5e-06 W=5e-06 AD=4.25e-12 AS=4.25e-12 PD=6.7e-06 PS=6.7e-06 NRD=0.085 NRS=0.085 $X=242625 $Y=130250 $D=41
M67 VDDA 11 9 VDDA pmos4 L=5e-06 W=5e-06 AD=4.25e-12 AS=4.25e-12 PD=6.7e-06 PS=6.7e-06 NRD=0.085 NRS=0.085 $X=242625 $Y=144550 $D=41
M68 VDDA 11 VOUT VDDA pmos4 L=5e-06 W=5e-06 AD=4.25e-12 AS=4.25e-12 PD=6.7e-06 PS=6.7e-06 NRD=0.085 NRS=0.085 $X=242625 $Y=158850 $D=41
M69 VDDA 11 VOUT VDDA pmos4 L=5e-06 W=5e-06 AD=4.25e-12 AS=4.25e-12 PD=6.7e-06 PS=6.7e-06 NRD=0.085 NRS=0.085 $X=242625 $Y=173150 $D=41
M70 VDDA 11 VOUT VDDA pmos4 L=5e-06 W=5e-06 AD=4.25e-12 AS=4.25e-12 PD=6.7e-06 PS=6.7e-06 NRD=0.085 NRS=0.085 $X=242625 $Y=187450 $D=41
M71 VDDA 11 VOUT VDDA pmos4 L=5e-06 W=5e-06 AD=4.25e-12 AS=4.25e-12 PD=6.7e-06 PS=6.7e-06 NRD=0.085 NRS=0.085 $X=249925 $Y=87350 $D=41
M72 VDDA 11 VOUT VDDA pmos4 L=5e-06 W=5e-06 AD=4.25e-12 AS=4.25e-12 PD=6.7e-06 PS=6.7e-06 NRD=0.085 NRS=0.085 $X=249925 $Y=101650 $D=41
M73 VDDA 11 VOUT VDDA pmos4 L=5e-06 W=5e-06 AD=4.25e-12 AS=4.25e-12 PD=6.7e-06 PS=6.7e-06 NRD=0.085 NRS=0.085 $X=249925 $Y=115950 $D=41
M74 VDDA 11 VOUT VDDA pmos4 L=5e-06 W=5e-06 AD=4.25e-12 AS=4.25e-12 PD=6.7e-06 PS=6.7e-06 NRD=0.085 NRS=0.085 $X=249925 $Y=130250 $D=41
M75 VDDA 11 VOUT VDDA pmos4 L=5e-06 W=5e-06 AD=4.25e-12 AS=4.25e-12 PD=6.7e-06 PS=6.7e-06 NRD=0.085 NRS=0.085 $X=249925 $Y=144550 $D=41
M76 VDDA 11 VOUT VDDA pmos4 L=5e-06 W=5e-06 AD=4.25e-12 AS=4.25e-12 PD=6.7e-06 PS=6.7e-06 NRD=0.085 NRS=0.085 $X=249925 $Y=158850 $D=41
M77 VDDA 11 VOUT VDDA pmos4 L=5e-06 W=5e-06 AD=4.25e-12 AS=4.25e-12 PD=6.7e-06 PS=6.7e-06 NRD=0.085 NRS=0.085 $X=249925 $Y=173150 $D=41
M78 VDDA 11 VOUT VDDA pmos4 L=5e-06 W=5e-06 AD=4.25e-12 AS=4.25e-12 PD=6.7e-06 PS=6.7e-06 NRD=0.085 NRS=0.085 $X=249925 $Y=187450 $D=41
M79 VDDA 11 VOUT VDDA pmos4 L=5e-06 W=5e-06 AD=4.25e-12 AS=4.25e-12 PD=6.7e-06 PS=6.7e-06 NRD=0.085 NRS=0.085 $X=257225 $Y=87350 $D=41
M80 VDDA 11 VOUT VDDA pmos4 L=5e-06 W=5e-06 AD=4.25e-12 AS=4.25e-12 PD=6.7e-06 PS=6.7e-06 NRD=0.085 NRS=0.085 $X=257225 $Y=101650 $D=41
M81 VDDA 11 VOUT VDDA pmos4 L=5e-06 W=5e-06 AD=4.25e-12 AS=4.25e-12 PD=6.7e-06 PS=6.7e-06 NRD=0.085 NRS=0.085 $X=257225 $Y=115950 $D=41
M82 VDDA 11 VOUT VDDA pmos4 L=5e-06 W=5e-06 AD=4.25e-12 AS=4.25e-12 PD=6.7e-06 PS=6.7e-06 NRD=0.085 NRS=0.085 $X=257225 $Y=130250 $D=41
M83 VDDA 11 VOUT VDDA pmos4 L=5e-06 W=5e-06 AD=4.25e-12 AS=4.25e-12 PD=6.7e-06 PS=6.7e-06 NRD=0.085 NRS=0.085 $X=257225 $Y=144550 $D=41
M84 VDDA 11 VOUT VDDA pmos4 L=5e-06 W=5e-06 AD=4.25e-12 AS=4.25e-12 PD=6.7e-06 PS=6.7e-06 NRD=0.085 NRS=0.085 $X=257225 $Y=158850 $D=41
M85 VDDA 11 VOUT VDDA pmos4 L=5e-06 W=5e-06 AD=4.25e-12 AS=4.25e-12 PD=6.7e-06 PS=6.7e-06 NRD=0.085 NRS=0.085 $X=257225 $Y=173150 $D=41
M86 VDDA 11 VOUT VDDA pmos4 L=5e-06 W=5e-06 AD=4.25e-12 AS=4.25e-12 PD=6.7e-06 PS=6.7e-06 NRD=0.085 NRS=0.085 $X=257225 $Y=187450 $D=41
M87 VDDA 11 VOUT VDDA pmos4 L=5e-06 W=5e-06 AD=4.25e-12 AS=4.25e-12 PD=6.7e-06 PS=6.7e-06 NRD=0.085 NRS=0.085 $X=264525 $Y=87350 $D=41
M88 VDDA 11 VOUT VDDA pmos4 L=5e-06 W=5e-06 AD=4.25e-12 AS=4.25e-12 PD=6.7e-06 PS=6.7e-06 NRD=0.085 NRS=0.085 $X=264525 $Y=101650 $D=41
M89 VDDA 11 VOUT VDDA pmos4 L=5e-06 W=5e-06 AD=4.25e-12 AS=4.25e-12 PD=6.7e-06 PS=6.7e-06 NRD=0.085 NRS=0.085 $X=264525 $Y=115950 $D=41
M90 VDDA 11 VOUT VDDA pmos4 L=5e-06 W=5e-06 AD=4.25e-12 AS=4.25e-12 PD=6.7e-06 PS=6.7e-06 NRD=0.085 NRS=0.085 $X=264525 $Y=130250 $D=41
M91 VDDA 11 VOUT VDDA pmos4 L=5e-06 W=5e-06 AD=4.25e-12 AS=4.25e-12 PD=6.7e-06 PS=6.7e-06 NRD=0.085 NRS=0.085 $X=264525 $Y=144550 $D=41
M92 VDDA 11 VOUT VDDA pmos4 L=5e-06 W=5e-06 AD=4.25e-12 AS=4.25e-12 PD=6.7e-06 PS=6.7e-06 NRD=0.085 NRS=0.085 $X=264525 $Y=158850 $D=41
M93 VDDA 11 VOUT VDDA pmos4 L=5e-06 W=5e-06 AD=4.25e-12 AS=4.25e-12 PD=6.7e-06 PS=6.7e-06 NRD=0.085 NRS=0.085 $X=264525 $Y=173150 $D=41
M94 VDDA 11 VOUT VDDA pmos4 L=5e-06 W=5e-06 AD=4.25e-12 AS=4.25e-12 PD=6.7e-06 PS=6.7e-06 NRD=0.085 NRS=0.085 $X=264525 $Y=187450 $D=41
M95 VDDA 11 VOUT VDDA pmos4 L=5e-06 W=5e-06 AD=4.25e-12 AS=4.25e-12 PD=6.7e-06 PS=6.7e-06 NRD=0.085 NRS=0.085 $X=271825 $Y=87350 $D=41
M96 VDDA 11 VOUT VDDA pmos4 L=5e-06 W=5e-06 AD=4.25e-12 AS=4.25e-12 PD=6.7e-06 PS=6.7e-06 NRD=0.085 NRS=0.085 $X=271825 $Y=101650 $D=41
M97 VDDA 11 VOUT VDDA pmos4 L=5e-06 W=5e-06 AD=4.25e-12 AS=4.25e-12 PD=6.7e-06 PS=6.7e-06 NRD=0.085 NRS=0.085 $X=271825 $Y=115950 $D=41
M98 VDDA 11 VOUT VDDA pmos4 L=5e-06 W=5e-06 AD=4.25e-12 AS=4.25e-12 PD=6.7e-06 PS=6.7e-06 NRD=0.085 NRS=0.085 $X=271825 $Y=130250 $D=41
M99 VDDA 11 VOUT VDDA pmos4 L=5e-06 W=5e-06 AD=4.25e-12 AS=4.25e-12 PD=6.7e-06 PS=6.7e-06 NRD=0.085 NRS=0.085 $X=271825 $Y=144550 $D=41
M100 VDDA 11 VOUT VDDA pmos4 L=5e-06 W=5e-06 AD=4.25e-12 AS=4.25e-12 PD=6.7e-06 PS=6.7e-06 NRD=0.085 NRS=0.085 $X=271825 $Y=158850 $D=41
M101 VDDA 11 VOUT VDDA pmos4 L=5e-06 W=5e-06 AD=4.25e-12 AS=4.25e-12 PD=6.7e-06 PS=6.7e-06 NRD=0.085 NRS=0.085 $X=271825 $Y=173150 $D=41
M102 VDDA 11 VOUT VDDA pmos4 L=5e-06 W=5e-06 AD=4.25e-12 AS=4.25e-12 PD=6.7e-06 PS=6.7e-06 NRD=0.085 NRS=0.085 $X=271825 $Y=187450 $D=41
M103 VDDA 11 VOUT VDDA pmos4 L=5e-06 W=5e-06 AD=4.25e-12 AS=4.25e-12 PD=6.7e-06 PS=6.7e-06 NRD=0.085 NRS=0.085 $X=279125 $Y=87350 $D=41
M104 VDDA 11 VOUT VDDA pmos4 L=5e-06 W=5e-06 AD=4.25e-12 AS=4.25e-12 PD=6.7e-06 PS=6.7e-06 NRD=0.085 NRS=0.085 $X=279125 $Y=101650 $D=41
M105 VDDA 11 VOUT VDDA pmos4 L=5e-06 W=5e-06 AD=4.25e-12 AS=4.25e-12 PD=6.7e-06 PS=6.7e-06 NRD=0.085 NRS=0.085 $X=279125 $Y=115950 $D=41
M106 VDDA 11 VOUT VDDA pmos4 L=5e-06 W=5e-06 AD=4.25e-12 AS=4.25e-12 PD=6.7e-06 PS=6.7e-06 NRD=0.085 NRS=0.085 $X=279125 $Y=130250 $D=41
M107 VDDA 11 VOUT VDDA pmos4 L=5e-06 W=5e-06 AD=4.25e-12 AS=4.25e-12 PD=6.7e-06 PS=6.7e-06 NRD=0.085 NRS=0.085 $X=279125 $Y=144550 $D=41
M108 VDDA 11 VOUT VDDA pmos4 L=5e-06 W=5e-06 AD=4.25e-12 AS=4.25e-12 PD=6.7e-06 PS=6.7e-06 NRD=0.085 NRS=0.085 $X=279125 $Y=158850 $D=41
M109 VDDA 11 VOUT VDDA pmos4 L=5e-06 W=5e-06 AD=4.25e-12 AS=4.25e-12 PD=6.7e-06 PS=6.7e-06 NRD=0.085 NRS=0.085 $X=279125 $Y=173150 $D=41
M110 VDDA 11 VOUT VDDA pmos4 L=5e-06 W=5e-06 AD=4.25e-12 AS=4.25e-12 PD=6.7e-06 PS=6.7e-06 NRD=0.085 NRS=0.085 $X=279125 $Y=187450 $D=41
M111 VDDA 11 VOUT VDDA pmos4 L=5e-06 W=5e-06 AD=4.25e-12 AS=4.25e-12 PD=6.7e-06 PS=6.7e-06 NRD=0.085 NRS=0.085 $X=286425 $Y=87350 $D=41
M112 VDDA 11 VOUT VDDA pmos4 L=5e-06 W=5e-06 AD=4.25e-12 AS=4.25e-12 PD=6.7e-06 PS=6.7e-06 NRD=0.085 NRS=0.085 $X=286425 $Y=101650 $D=41
M113 VDDA 11 VOUT VDDA pmos4 L=5e-06 W=5e-06 AD=4.25e-12 AS=4.25e-12 PD=6.7e-06 PS=6.7e-06 NRD=0.085 NRS=0.085 $X=286425 $Y=115950 $D=41
M114 VDDA 11 VOUT VDDA pmos4 L=5e-06 W=5e-06 AD=4.25e-12 AS=4.25e-12 PD=6.7e-06 PS=6.7e-06 NRD=0.085 NRS=0.085 $X=286425 $Y=130250 $D=41
M115 VDDA 11 VOUT VDDA pmos4 L=5e-06 W=5e-06 AD=4.25e-12 AS=4.25e-12 PD=6.7e-06 PS=6.7e-06 NRD=0.085 NRS=0.085 $X=286425 $Y=144550 $D=41
M116 VDDA 11 VOUT VDDA pmos4 L=5e-06 W=5e-06 AD=4.25e-12 AS=4.25e-12 PD=6.7e-06 PS=6.7e-06 NRD=0.085 NRS=0.085 $X=286425 $Y=158850 $D=41
M117 VDDA 11 VOUT VDDA pmos4 L=5e-06 W=5e-06 AD=4.25e-12 AS=4.25e-12 PD=6.7e-06 PS=6.7e-06 NRD=0.085 NRS=0.085 $X=286425 $Y=173150 $D=41
M118 VDDA 11 VOUT VDDA pmos4 L=5e-06 W=5e-06 AD=4.25e-12 AS=4.25e-12 PD=6.7e-06 PS=6.7e-06 NRD=0.085 NRS=0.085 $X=286425 $Y=187450 $D=41
M119 VDDA 11 VOUT VDDA pmos4 L=5e-06 W=5e-06 AD=4.25e-12 AS=4.25e-12 PD=6.7e-06 PS=6.7e-06 NRD=0.085 NRS=0.085 $X=293725 $Y=87350 $D=41
M120 VDDA 11 VOUT VDDA pmos4 L=5e-06 W=5e-06 AD=4.25e-12 AS=4.25e-12 PD=6.7e-06 PS=6.7e-06 NRD=0.085 NRS=0.085 $X=293725 $Y=101650 $D=41
M121 VDDA 11 VOUT VDDA pmos4 L=5e-06 W=5e-06 AD=4.25e-12 AS=4.25e-12 PD=6.7e-06 PS=6.7e-06 NRD=0.085 NRS=0.085 $X=293725 $Y=115950 $D=41
M122 VDDA 11 VOUT VDDA pmos4 L=5e-06 W=5e-06 AD=4.25e-12 AS=4.25e-12 PD=6.7e-06 PS=6.7e-06 NRD=0.085 NRS=0.085 $X=293725 $Y=130250 $D=41
M123 VDDA 11 VOUT VDDA pmos4 L=5e-06 W=5e-06 AD=4.25e-12 AS=4.25e-12 PD=6.7e-06 PS=6.7e-06 NRD=0.085 NRS=0.085 $X=293725 $Y=144550 $D=41
M124 VDDA 11 VOUT VDDA pmos4 L=5e-06 W=5e-06 AD=4.25e-12 AS=4.25e-12 PD=6.7e-06 PS=6.7e-06 NRD=0.085 NRS=0.085 $X=293725 $Y=158850 $D=41
M125 VDDA 11 VOUT VDDA pmos4 L=5e-06 W=5e-06 AD=4.25e-12 AS=4.25e-12 PD=6.7e-06 PS=6.7e-06 NRD=0.085 NRS=0.085 $X=293725 $Y=173150 $D=41
M126 VDDA 11 VOUT VDDA pmos4 L=5e-06 W=5e-06 AD=4.25e-12 AS=4.25e-12 PD=6.7e-06 PS=6.7e-06 NRD=0.085 NRS=0.085 $X=293725 $Y=187450 $D=41
M127 VDDA 11 VOUT VDDA pmos4 L=5e-06 W=5e-06 AD=4.25e-12 AS=4.25e-12 PD=6.7e-06 PS=6.7e-06 NRD=0.085 NRS=0.085 $X=301025 $Y=87350 $D=41
M128 VDDA 11 VOUT VDDA pmos4 L=5e-06 W=5e-06 AD=4.25e-12 AS=4.25e-12 PD=6.7e-06 PS=6.7e-06 NRD=0.085 NRS=0.085 $X=301025 $Y=101650 $D=41
M129 VDDA 11 VOUT VDDA pmos4 L=5e-06 W=5e-06 AD=4.25e-12 AS=4.25e-12 PD=6.7e-06 PS=6.7e-06 NRD=0.085 NRS=0.085 $X=301025 $Y=115950 $D=41
M130 VDDA 11 VOUT VDDA pmos4 L=5e-06 W=5e-06 AD=4.25e-12 AS=4.25e-12 PD=6.7e-06 PS=6.7e-06 NRD=0.085 NRS=0.085 $X=301025 $Y=130250 $D=41
M131 VDDA 11 VOUT VDDA pmos4 L=5e-06 W=5e-06 AD=4.25e-12 AS=4.25e-12 PD=6.7e-06 PS=6.7e-06 NRD=0.085 NRS=0.085 $X=301025 $Y=144550 $D=41
M132 VDDA 11 VOUT VDDA pmos4 L=5e-06 W=5e-06 AD=4.25e-12 AS=4.25e-12 PD=6.7e-06 PS=6.7e-06 NRD=0.085 NRS=0.085 $X=301025 $Y=158850 $D=41
M133 VDDA 11 VOUT VDDA pmos4 L=5e-06 W=5e-06 AD=4.25e-12 AS=4.25e-12 PD=6.7e-06 PS=6.7e-06 NRD=0.085 NRS=0.085 $X=301025 $Y=173150 $D=41
M134 VDDA 11 VOUT VDDA pmos4 L=5e-06 W=5e-06 AD=4.25e-12 AS=4.25e-12 PD=6.7e-06 PS=6.7e-06 NRD=0.085 NRS=0.085 $X=301025 $Y=187450 $D=41
M135 VDDA 11 VOUT VDDA pmos4 L=5e-06 W=5e-06 AD=4.25e-12 AS=4.25e-12 PD=6.7e-06 PS=6.7e-06 NRD=0.085 NRS=0.085 $X=308325 $Y=87350 $D=41
M136 VDDA 11 VOUT VDDA pmos4 L=5e-06 W=5e-06 AD=4.25e-12 AS=4.25e-12 PD=6.7e-06 PS=6.7e-06 NRD=0.085 NRS=0.085 $X=308325 $Y=101650 $D=41
M137 VDDA 11 VOUT VDDA pmos4 L=5e-06 W=5e-06 AD=4.25e-12 AS=4.25e-12 PD=6.7e-06 PS=6.7e-06 NRD=0.085 NRS=0.085 $X=308325 $Y=115950 $D=41
M138 VDDA 11 9 VDDA pmos4 L=5e-06 W=5e-06 AD=4.25e-12 AS=4.25e-12 PD=6.7e-06 PS=6.7e-06 NRD=0.085 NRS=0.085 $X=308325 $Y=130250 $D=41
M139 VDDA 11 9 VDDA pmos4 L=5e-06 W=5e-06 AD=4.25e-12 AS=4.25e-12 PD=6.7e-06 PS=6.7e-06 NRD=0.085 NRS=0.085 $X=308325 $Y=144550 $D=41
M140 VDDA 11 VOUT VDDA pmos4 L=5e-06 W=5e-06 AD=4.25e-12 AS=4.25e-12 PD=6.7e-06 PS=6.7e-06 NRD=0.085 NRS=0.085 $X=308325 $Y=158850 $D=41
M141 VDDA 11 VOUT VDDA pmos4 L=5e-06 W=5e-06 AD=4.25e-12 AS=4.25e-12 PD=6.7e-06 PS=6.7e-06 NRD=0.085 NRS=0.085 $X=308325 $Y=173150 $D=41
M142 VDDA 11 VOUT VDDA pmos4 L=5e-06 W=5e-06 AD=4.25e-12 AS=4.25e-12 PD=6.7e-06 PS=6.7e-06 NRD=0.085 NRS=0.085 $X=308325 $Y=187450 $D=41
M143 VDDA 11 VOUT VDDA pmos4 L=5e-06 W=5e-06 AD=4.25e-12 AS=4.25e-12 PD=6.7e-06 PS=6.7e-06 NRD=0.085 NRS=0.085 $X=315625 $Y=87350 $D=41
M144 VDDA 11 VOUT VDDA pmos4 L=5e-06 W=5e-06 AD=4.25e-12 AS=4.25e-12 PD=6.7e-06 PS=6.7e-06 NRD=0.085 NRS=0.085 $X=315625 $Y=101650 $D=41
M145 VDDA 11 VOUT VDDA pmos4 L=5e-06 W=5e-06 AD=4.25e-12 AS=4.25e-12 PD=6.7e-06 PS=6.7e-06 NRD=0.085 NRS=0.085 $X=315625 $Y=115950 $D=41
M146 VDDA 11 9 VDDA pmos4 L=5e-06 W=5e-06 AD=4.25e-12 AS=4.25e-12 PD=6.7e-06 PS=6.7e-06 NRD=0.085 NRS=0.085 $X=315625 $Y=130250 $D=41
M147 VDDA 11 9 VDDA pmos4 L=5e-06 W=5e-06 AD=4.25e-12 AS=4.25e-12 PD=6.7e-06 PS=6.7e-06 NRD=0.085 NRS=0.085 $X=315625 $Y=144550 $D=41
M148 VDDA 11 VOUT VDDA pmos4 L=5e-06 W=5e-06 AD=4.25e-12 AS=4.25e-12 PD=6.7e-06 PS=6.7e-06 NRD=0.085 NRS=0.085 $X=315625 $Y=158850 $D=41
M149 VDDA 11 VOUT VDDA pmos4 L=5e-06 W=5e-06 AD=4.25e-12 AS=4.25e-12 PD=6.7e-06 PS=6.7e-06 NRD=0.085 NRS=0.085 $X=315625 $Y=173150 $D=41
M150 VDDA 11 VOUT VDDA pmos4 L=5e-06 W=5e-06 AD=4.25e-12 AS=4.25e-12 PD=6.7e-06 PS=6.7e-06 NRD=0.085 NRS=0.085 $X=315625 $Y=187450 $D=41
M151 VDDA 11 VOUT VDDA pmos4 L=5e-06 W=5e-06 AD=4.25e-12 AS=4.25e-12 PD=6.7e-06 PS=6.7e-06 NRD=0.085 NRS=0.085 $X=322925 $Y=87350 $D=41
M152 VDDA 11 VOUT VDDA pmos4 L=5e-06 W=5e-06 AD=4.25e-12 AS=4.25e-12 PD=6.7e-06 PS=6.7e-06 NRD=0.085 NRS=0.085 $X=322925 $Y=101650 $D=41
M153 VDDA 11 VOUT VDDA pmos4 L=5e-06 W=5e-06 AD=4.25e-12 AS=4.25e-12 PD=6.7e-06 PS=6.7e-06 NRD=0.085 NRS=0.085 $X=322925 $Y=115950 $D=41
M154 VDDA 11 11 VDDA pmos4 L=5e-06 W=5e-06 AD=4.25e-12 AS=4.25e-12 PD=6.7e-06 PS=6.7e-06 NRD=0.085 NRS=0.085 $X=322925 $Y=130250 $D=41
M155 VDDA 11 9 VDDA pmos4 L=5e-06 W=5e-06 AD=4.25e-12 AS=4.25e-12 PD=6.7e-06 PS=6.7e-06 NRD=0.085 NRS=0.085 $X=322925 $Y=144550 $D=41
M156 VDDA 11 VOUT VDDA pmos4 L=5e-06 W=5e-06 AD=4.25e-12 AS=4.25e-12 PD=6.7e-06 PS=6.7e-06 NRD=0.085 NRS=0.085 $X=322925 $Y=158850 $D=41
M157 VDDA 11 VOUT VDDA pmos4 L=5e-06 W=5e-06 AD=4.25e-12 AS=4.25e-12 PD=6.7e-06 PS=6.7e-06 NRD=0.085 NRS=0.085 $X=322925 $Y=173150 $D=41
M158 VDDA 11 VOUT VDDA pmos4 L=5e-06 W=5e-06 AD=4.25e-12 AS=4.25e-12 PD=6.7e-06 PS=6.7e-06 NRD=0.085 NRS=0.085 $X=322925 $Y=187450 $D=41
C159 GNDA VDDA $[cpolya] $A=3500 $P=330 $X=205150 $Y=20700 $D=58
X176 GNDA VDDA cpolyc_CDNS_78073660103112 $T=17350 77325 0 270 $X=16000 $Y=33175
X179 VOUT 10 cpolyc_CDNS_78073660103138 $T=17225 138850 0 0 $X=15875 $Y=137500
X180 VOUT 10 cpolyc_CDNS_78073660103138 $T=194375 138850 1 180 $X=106475 $Y=137500
X181 18 12 rpolyhc_CDNS_78073660103136 $T=82025 116350 1 0 $X=76025 $Y=104700
X182 13 18 rpolyhc_CDNS_78073660103136 $T=131025 126650 0 180 $X=76025 $Y=115000
X183 VOUT 15 14 ICV_53 $T=27025 88750 0 0 $X=21025 $Y=84100
X184 14 16 13 ICV_53 $T=27025 109350 0 0 $X=21025 $Y=104700
X185 CBUF 17 12 ICV_53 $T=131025 88750 1 180 $X=76025 $Y=84100
X186 9 7 8 12 VIN VDDA ICV_52 $T=105750 34800 0 90 $X=100850 $Y=33600
X187 9 8 7 VIN 12 VDDA ICV_52 $T=105750 52600 0 90 $X=100850 $Y=51400
X188 9 8 7 VDDA VIN 12 ICV_54 $T=71350 34800 0 90 $X=66450 $Y=33600
X189 9 7 8 VDDA 12 VIN ICV_54 $T=71350 52600 0 90 $X=66450 $Y=51400
X190 GNDA 7 7 nmos4_CDNS_78073660103140 $T=150275 26100 0 90 $X=144325 $Y=25700
X191 GNDA 8 7 nmos4_CDNS_78073660103140 $T=151375 26100 1 90 $X=151125 $Y=25700
X192 GNDA 11 IBIAS nmos4_CDNS_78073660103141 $T=182025 26100 0 90 $X=170075 $Y=25700
X193 GNDA IBIAS IBIAS nmos4_CDNS_78073660103141 $T=183125 26100 1 90 $X=182875 $Y=25700
X196 VDDA ICV_50 $T=226575 73050 0 90 $X=218675 $Y=71850
X197 VDDA ICV_50 $T=226575 87350 0 90 $X=218675 $Y=86150
X198 VDDA ICV_50 $T=226575 101650 0 90 $X=218675 $Y=100450
X199 VDDA ICV_50 $T=226575 115950 0 90 $X=218675 $Y=114750
X200 VDDA ICV_50 $T=226575 130250 0 90 $X=218675 $Y=129050
X201 VDDA ICV_50 $T=226575 144550 0 90 $X=218675 $Y=143350
X202 VDDA ICV_50 $T=226575 158850 0 90 $X=218675 $Y=157650
X203 VDDA ICV_50 $T=226575 173150 0 90 $X=218675 $Y=171950
X204 VDDA ICV_50 $T=226575 187450 0 90 $X=218675 $Y=186250
X205 VDDA ICV_50 $T=226575 201750 0 90 $X=218675 $Y=200550
.ENDS
***************************************
.SUBCKT ECG_Front_End VINP VINN F<0> F<1> F<2> VREF_CM CM EN_CMFB 9 VDDA GNDA BIAS7 BIAS4 S<0> CVGA S<1> S<2> CMFB S<3> BIAS2
+ BIAS3 BIAS5 VDDD EXC1 EXC2 CBUF BIAS6 OUT GNDD VREF BIAS1 CLK
** N=72 EP=32 IP=146 FDC=2505
D0 GNDA VDDA p_nwd AREA=165.435 PJ=66.1 $X=411150 $Y=904300 $D=87
D1 GNDA VDDA p_nwd AREA=163.68 PJ=65.2 $X=411650 $Y=602950 $D=87
D2 GNDA VDDA p_nwd AREA=160.43 PJ=64.8 $X=1451050 $Y=603050 $D=87
X3 VDDA GNDA V500_20 $T=345350 348700 0 0 $X=345150 $Y=348650
X4 VDDA GNDA V500_20 $T=347650 675300 1 0 $X=347450 $Y=651200
X5 VDDA GNDA V500_20 $T=352250 955950 0 0 $X=352050 $Y=955900
X6 VDDA GNDA V500_20 $T=1146050 108550 1 0 $X=1145850 $Y=84450
X7 VDDA GNDA V500_20 $T=1214600 904850 0 0 $X=1214400 $Y=904800
X8 VDDA GNDA V500_20 $T=1223900 675300 1 0 $X=1223700 $Y=651200
X9 VDDA GNDA V500_20 $T=1235050 76950 1 0 $X=1234850 $Y=52850
X10 VDDA GNDA V500_20 $T=1248900 348700 0 0 $X=1248700 $Y=348650
X11 VDDA GNDA V500_20 $T=1256350 955950 0 0 $X=1256150 $Y=955900
X12 VDDA GNDA V500_20 $T=2132925 608050 0 270 $X=2132875 $Y=113550
X13 CM VREF_CM EN_CMFB BIAS7 VDDA GNDA VINP VINN CMFB 69 fecg_cmfb2_fc $T=1058300 128700 0 0 $X=1066550 $Y=134548
X14 VDDA GNDA V1000_20 $T=91650 76950 1 0 $X=91450 $Y=52850
X15 VDDA GNDA V200_20 $T=1026825 324425 0 270 $X=1026775 $Y=124375
X16 VDDA GNDA V200_20 $T=1089925 610275 0 270 $X=1089875 $Y=410225
X17 VDDA GNDA V200_20 $T=1089925 903025 0 270 $X=1089875 $Y=702975
X18 VDDA GNDA V200_20 $T=1653025 321325 0 270 $X=1652975 $Y=121275
X19 VDDA GNDA V200_20 $T=1776375 888125 0 270 $X=1776325 $Y=688075
X20 VDDA GNDA V200_20 $T=1797600 83100 0 0 $X=1797650 $Y=83050
X21 VDDA GNDA V200_20 $T=2036325 321375 0 270 $X=2036275 $Y=121325
X22 VDDA GNDA V200_20 $T=2080475 310775 0 270 $X=2080425 $Y=110725
X23 64 35 VDDA 36 63 BIAS2 40 39 F<0> 42 44 46 GNDA 53 9 F<1> F<2> Gm_C_filter $T=56325 661900 0 0 $X=83850 $Y=382748
X24 66 37 VDDA 38 65 BIAS3 41 9 F<0> 43 45 47 GNDA 39 9 F<1> F<2> Gm_C_filter $T=56325 963150 0 0 $X=83850 $Y=683998
X25 71 54 VDDA 55 70 BIAS5 57 56 F<0> 58 59 60 GNDA 34 56 F<1> F<2> Gm_C_filter $T=1095700 661900 0 0 $X=1123225 $Y=382748
X26 GNDA 50 48 BIAS1 51 49 VDDA 52 53 VDDD GNDD VINN EXC1 VINP EXC2 67 68 VREF CLK ia_new_f $T=92600 -53150 0 0 $X=90200 $Y=79050
X27 34 VDDA 61 BIAS4 GNDA 9 S<0> CVGA 72 S<1> S<2> 62 S<3> VGA_1 $T=1120800 700050 0 0 $X=1123225 $Y=683498
X28 VDDA OUT 56 CBUF BIAS6 GNDA BUFFER $T=1672800 105125 0 0 $X=1683000 $Y=116998
.ENDS
***************************************
.SUBCKT pmos4_CDNS_78073660103118 1
** N=2 EP=1 IP=0 FDC=1
M0 1 1 1 1 pmos4 L=1e-05 W=1e-06 AD=8.5e-13 AS=8.5e-13 PD=2.7e-06 PS=2.7e-06 NRD=0.425 NRS=0.425 $X=0 $Y=850 $D=42
.ENDS
***************************************
.SUBCKT ICV_46 1
*.CALIBRE ICV_CELL 9
** N=2 EP=1 IP=4 FDC=2
X0 1 pmos4_CDNS_78073660103118 $T=0 0 0 0 $X=-1200 $Y=-1200
X1 1 pmos4_CDNS_78073660103118 $T=0 12300 0 0 $X=-1200 $Y=11100
.ENDS
***************************************
.SUBCKT pmos4_CDNS_78073660103117
** N=4 EP=0 IP=0 FDC=0
.ENDS
***************************************
.SUBCKT ICV_39
** N=6 EP=0 IP=8 FDC=0
.ENDS
***************************************
.SUBCKT ICV_40 1 2 3 5
** N=7 EP=4 IP=12 FDC=3
M0 1 1 1 1 pmos4 L=1e-05 W=1e-05 AD=8.5e-12 AS=8.5e-12 PD=1.17e-05 PS=1.17e-05 NRD=0.0425 NRS=0.0425 $X=0 $Y=850 $D=42
M1 2 5 1 1 pmos4 L=1e-05 W=1e-05 AD=8.5e-12 AS=8.5e-12 PD=1.17e-05 PS=1.17e-05 NRD=0.0425 NRS=0.0425 $X=0 $Y=13150 $D=41
M2 3 5 1 1 pmos4 L=1e-05 W=1e-05 AD=8.5e-12 AS=8.5e-12 PD=1.17e-05 PS=1.17e-05 NRD=0.0425 NRS=0.0425 $X=0 $Y=25450 $D=41
.ENDS
***************************************
.SUBCKT ICV_34
** N=7 EP=0 IP=8 FDC=0
.ENDS
***************************************
.SUBCKT pmos4_CDNS_78073660103116 1 2 3 5
** N=5 EP=4 IP=0 FDC=1
M0 2 3 1 5 pmos4 L=1e-05 W=2e-05 AD=1.7e-11 AS=1.7e-11 PD=2.17e-05 PS=2.17e-05 NRD=0.02125 NRS=0.02125 $X=0 $Y=850 $D=41
.ENDS
***************************************
.SUBCKT pmos4_CDNS_7807366010317 1 2 3 5
** N=5 EP=4 IP=0 FDC=1
M0 2 3 1 5 pmos4 L=1e-06 W=5e-06 AD=4.25e-12 AS=4.25e-12 PD=6.7e-06 PS=6.7e-06 NRD=0.085 NRS=0.085 $X=0 $Y=850 $D=41
.ENDS
***************************************
.SUBCKT Constant_gm VDDA GNDA IBIAS1 IBIAS2 IBIAS3
** N=17 EP=5 IP=178 FDC=63
R0 17 GNDA L=0.00065265 W=2e-06 $[rpolyh] $X=386100 $Y=-154150 $D=17
D1 GNDA VDDA p_nwd AREA=16865 PJ=519.5 $X=123175 $Y=-159950 $D=87
D2 GNDA VDDA p_nwd AREA=1275.12 PJ=143.6 $X=258700 $Y=-125850 $D=87
D3 GNDA VDDA p_nwd AREA=6622.88 PJ=343.8 $X=258700 $Y=-86800 $D=87
M4 GNDA GNDA GNDA GNDA nmos4 L=1e-05 W=1e-05 AD=8.5e-12 AS=8.5e-12 PD=1.17e-05 PS=1.17e-05 NRD=0.0425 NRS=0.0425 $X=262500 $Y=-153800 $D=38
M5 GNDA GNDA GNDA GNDA nmos4 L=1e-05 W=1e-05 AD=8.5e-12 AS=8.5e-12 PD=1.17e-05 PS=1.17e-05 NRD=0.0425 NRS=0.0425 $X=336300 $Y=-153800 $D=38
M6 16 11 17 GNDA nmos4 L=1e-05 W=1e-05 AD=8.5e-12 AS=8.5e-12 PD=1.17e-05 PS=1.17e-05 NRD=0.0425 NRS=0.0425 $X=274800 $Y=-153800 $D=37
M7 16 11 17 GNDA nmos4 L=1e-05 W=1e-05 AD=8.5e-12 AS=8.5e-12 PD=1.17e-05 PS=1.17e-05 NRD=0.0425 NRS=0.0425 $X=287100 $Y=-153800 $D=37
M8 11 11 GNDA GNDA nmos4 L=1e-05 W=1e-05 AD=8.5e-12 AS=8.5e-12 PD=1.17e-05 PS=1.17e-05 NRD=0.0425 NRS=0.0425 $X=299400 $Y=-153800 $D=37
M9 16 11 17 GNDA nmos4 L=1e-05 W=1e-05 AD=8.5e-12 AS=8.5e-12 PD=1.17e-05 PS=1.17e-05 NRD=0.0425 NRS=0.0425 $X=311700 $Y=-153800 $D=37
M10 12 12 11 GNDA nmos4 L=1e-05 W=1e-05 AD=8.5e-12 AS=8.5e-12 PD=1.17e-05 PS=1.17e-05 NRD=0.0425 NRS=0.0425 $X=313250 $Y=-119750 $D=37
M11 16 11 17 GNDA nmos4 L=1e-05 W=1e-05 AD=8.5e-12 AS=8.5e-12 PD=1.17e-05 PS=1.17e-05 NRD=0.0425 NRS=0.0425 $X=324000 $Y=-153800 $D=37
M12 13 12 16 GNDA nmos4 L=1e-05 W=1e-05 AD=8.5e-12 AS=8.5e-12 PD=1.17e-05 PS=1.17e-05 NRD=0.0425 NRS=0.0425 $X=325550 $Y=-119750 $D=37
M13 13 12 16 GNDA nmos4 L=1e-05 W=1e-05 AD=8.5e-12 AS=8.5e-12 PD=1.17e-05 PS=1.17e-05 NRD=0.0425 NRS=0.0425 $X=337850 $Y=-119750 $D=37
M14 13 12 16 GNDA nmos4 L=1e-05 W=1e-05 AD=8.5e-12 AS=8.5e-12 PD=1.17e-05 PS=1.17e-05 NRD=0.0425 NRS=0.0425 $X=350150 $Y=-119750 $D=37
M15 13 12 16 GNDA nmos4 L=1e-05 W=1e-05 AD=8.5e-12 AS=8.5e-12 PD=1.17e-05 PS=1.17e-05 NRD=0.0425 NRS=0.0425 $X=362450 $Y=-119750 $D=37
M16 VDDA VDDA VDDA VDDA pmos4 L=1e-05 W=1e-05 AD=8.5e-12 AS=8.5e-12 PD=1.17e-05 PS=1.17e-05 NRD=0.0425 NRS=0.0425 $X=213075 $Y=-136250 $D=42
M17 VDDA VDDA VDDA VDDA pmos4 L=1e-05 W=1e-05 AD=8.5e-12 AS=8.5e-12 PD=1.17e-05 PS=1.17e-05 NRD=0.0425 NRS=0.0425 $X=213075 $Y=-111450 $D=42
M18 VDDA VDDA VDDA VDDA pmos4 L=1e-05 W=1e-05 AD=8.5e-12 AS=8.5e-12 PD=1.17e-05 PS=1.17e-05 NRD=0.0425 NRS=0.0425 $X=213075 $Y=-86650 $D=42
M19 VDDA VDDA VDDA VDDA pmos4 L=1e-05 W=1e-05 AD=8.5e-12 AS=8.5e-12 PD=1.17e-05 PS=1.17e-05 NRD=0.0425 NRS=0.0425 $X=213075 $Y=-61850 $D=42
M20 6 8 VDDA VDDA pmos4 L=1e-05 W=1e-05 AD=8.5e-12 AS=8.5e-12 PD=1.17e-05 PS=1.17e-05 NRD=0.0425 NRS=0.0425 $X=188475 $Y=-136250 $D=41
M21 9 8 VDDA VDDA pmos4 L=1e-05 W=1e-05 AD=8.5e-12 AS=8.5e-12 PD=1.17e-05 PS=1.17e-05 NRD=0.0425 NRS=0.0425 $X=188475 $Y=-111450 $D=41
M22 8 8 VDDA VDDA pmos4 L=1e-05 W=1e-05 AD=8.5e-12 AS=8.5e-12 PD=1.17e-05 PS=1.17e-05 NRD=0.0425 NRS=0.0425 $X=188475 $Y=-86650 $D=41
M23 6 8 VDDA VDDA pmos4 L=1e-05 W=1e-05 AD=8.5e-12 AS=8.5e-12 PD=1.17e-05 PS=1.17e-05 NRD=0.0425 NRS=0.0425 $X=188475 $Y=-61850 $D=41
M24 7 8 VDDA VDDA pmos4 L=1e-05 W=1e-05 AD=8.5e-12 AS=8.5e-12 PD=1.17e-05 PS=1.17e-05 NRD=0.0425 NRS=0.0425 $X=200775 $Y=-136250 $D=41
M25 10 8 VDDA VDDA pmos4 L=1e-05 W=1e-05 AD=8.5e-12 AS=8.5e-12 PD=1.17e-05 PS=1.17e-05 NRD=0.0425 NRS=0.0425 $X=200775 $Y=-111450 $D=41
M26 10 8 VDDA VDDA pmos4 L=1e-05 W=1e-05 AD=8.5e-12 AS=8.5e-12 PD=1.17e-05 PS=1.17e-05 NRD=0.0425 NRS=0.0425 $X=200775 $Y=-86650 $D=41
M27 7 8 VDDA VDDA pmos4 L=1e-05 W=1e-05 AD=8.5e-12 AS=8.5e-12 PD=1.17e-05 PS=1.17e-05 NRD=0.0425 NRS=0.0425 $X=200775 $Y=-61850 $D=41
X38 VDDA ICV_46 $T=150725 -151050 0 270 $X=149525 $Y=-153250
X39 VDDA ICV_46 $T=150725 -36050 0 270 $X=149525 $Y=-38250
X40 VDDA ICV_46 $T=175325 -151050 0 270 $X=174125 $Y=-153250
X41 VDDA ICV_46 $T=175325 -36050 0 270 $X=174125 $Y=-38250
X42 VDDA ICV_46 $T=199925 -151050 0 270 $X=198725 $Y=-153250
X43 VDDA ICV_46 $T=199925 -36050 0 270 $X=198725 $Y=-38250
X48 VDDA 7 6 8 ICV_40 $T=150725 -126250 0 270 $X=149525 $Y=-137450
X49 VDDA 10 8 8 ICV_40 $T=150725 -101450 0 270 $X=149525 $Y=-112650
X50 VDDA 10 9 8 ICV_40 $T=150725 -76650 0 270 $X=149525 $Y=-87850
X51 VDDA 7 6 8 ICV_40 $T=150725 -51850 0 270 $X=149525 $Y=-63050
X57 6 IBIAS2 13 VDDA pmos4_CDNS_78073660103116 $T=266600 -43450 0 270 $X=265400 $Y=-64650
X58 10 IBIAS1 13 VDDA pmos4_CDNS_78073660103116 $T=278900 -43450 0 270 $X=277700 $Y=-64650
X59 7 IBIAS3 13 VDDA pmos4_CDNS_78073660103116 $T=291200 -43450 0 270 $X=290000 $Y=-64650
X60 8 13 13 VDDA pmos4_CDNS_78073660103116 $T=303500 -43450 0 270 $X=302300 $Y=-64650
X61 9 12 13 VDDA pmos4_CDNS_78073660103116 $T=315800 -43450 0 270 $X=314600 $Y=-64650
X62 7 IBIAS3 13 VDDA pmos4_CDNS_78073660103116 $T=328100 -43450 0 270 $X=326900 $Y=-64650
X63 10 IBIAS1 13 VDDA pmos4_CDNS_78073660103116 $T=340400 -43450 0 270 $X=339200 $Y=-64650
X64 6 IBIAS2 13 VDDA pmos4_CDNS_78073660103116 $T=352700 -43450 0 270 $X=351500 $Y=-64650
X65 13 15 15 VDDA pmos4_CDNS_7807366010317 $T=273850 -108600 0 270 $X=272650 $Y=-114800
X66 15 14 14 VDDA pmos4_CDNS_7807366010317 $T=277150 -108600 0 270 $X=275950 $Y=-114800
X67 14 12 12 VDDA pmos4_CDNS_7807366010317 $T=280450 -108600 0 270 $X=279250 $Y=-114800
.ENDS
***************************************
.SUBCKT nmos4_CDNS_78073660103127 1 2 3 4
** N=4 EP=4 IP=0 FDC=1
M0 2 3 1 4 nmos4 L=5e-06 W=1e-05 AD=8.5e-12 AS=8.5e-12 PD=1.17e-05 PS=1.17e-05 NRD=0.0425 NRS=0.0425 $X=0 $Y=850 $D=37
.ENDS
***************************************
.SUBCKT P1_C_CDNS_78073660103430
** N=2 EP=0 IP=0 FDC=0
.ENDS
***************************************
.SUBCKT nmos4_CDNS_78073660103132
** N=3 EP=0 IP=0 FDC=0
.ENDS
***************************************
.SUBCKT P1_C_CDNS_78073660103429
** N=2 EP=0 IP=0 FDC=0
.ENDS
***************************************
.SUBCKT nmos4_CDNS_78073660103131
** N=3 EP=0 IP=0 FDC=0
.ENDS
***************************************
.SUBCKT pmos4_CDNS_780736601033
** N=5 EP=0 IP=0 FDC=0
.ENDS
***************************************
.SUBCKT ICV_15
** N=6 EP=0 IP=10 FDC=0
.ENDS
***************************************
.SUBCKT ICV_16
** N=10 EP=0 IP=12 FDC=0
.ENDS
***************************************
.SUBCKT ICV_43 1
** N=16 EP=1 IP=30 FDC=1
M0 1 1 1 1 pmos4 L=1e-05 W=5e-06 AD=4.25e-12 AS=4.25e-12 PD=6.7e-06 PS=6.7e-06 NRD=0.085 NRS=0.085 $X=0 $Y=850 $D=42
.ENDS
***************************************
.SUBCKT nmos4_CDNS_780736601034
** N=4 EP=0 IP=0 FDC=0
.ENDS
***************************************
.SUBCKT ICV_45 1 2 4
** N=4 EP=3 IP=8 FDC=1
M0 2 4 1 1 nmos4 L=1e-05 W=5e-06 AD=4.25e-12 AS=4.25e-12 PD=6.7e-06 PS=6.7e-06 NRD=0.085 NRS=0.085 $X=0 $Y=-11450 $D=37
.ENDS
***************************************
.SUBCKT pmos4_CDNS_7807366010314
** N=5 EP=0 IP=0 FDC=0
.ENDS
***************************************
.SUBCKT pmos4_CDNS_78073660103133
** N=4 EP=0 IP=0 FDC=0
.ENDS
***************************************
.SUBCKT ICV_44
** N=6 EP=0 IP=8 FDC=0
.ENDS
***************************************
.SUBCKT vert10_4 1 2
** N=2 EP=2 IP=0 FDC=1
Q0 2 2 1 pnpvert10 AREA=1e-12 $X=1400 $Y=1400 $D=33
.ENDS
***************************************
.SUBCKT ICV_41 1 2 3
*.CALIBRE ICV_CELL 9
** N=3 EP=3 IP=4 FDC=2
X0 1 2 vert10_4 $T=0 0 0 0 $X=0 $Y=0
X1 3 2 vert10_4 $T=17400 0 0 0 $X=17400 $Y=0
.ENDS
***************************************
.SUBCKT ICV_42 1 2 3
*.CALIBRE ICV_CELL 9
** N=3 EP=3 IP=6 FDC=4
X0 1 1 2 ICV_41 $T=0 0 0 0 $X=0 $Y=0
X1 2 1 3 ICV_41 $T=34800 0 0 0 $X=34800 $Y=0
.ENDS
***************************************
.SUBCKT rpolyhc_CDNS_78073660103126 1 2
** N=3 EP=2 IP=0 FDC=1
R0 1 2 L=0.00473787 W=1e-05 $[rpolyh] $X=-10200 $Y=16800 $D=17
.ENDS
***************************************
.SUBCKT ECG_bandgap_f_v1 GNDA VDDA BG_REF BIAS
** N=21 EP=4 IP=772 FDC=268
R0 18 BG_REF L=0.000163345 W=1e-05 $[rpolyh] $X=28950 $Y=557250 $D=17
R1 15 20 L=0.000653373 W=1e-05 $[rpolyh] $X=172750 $Y=605250 $D=17
D2 GNDA VDDA p_nwd AREA=7277.53 PJ=453.5 $X=31000 $Y=847600 $D=87
D3 GNDA 10 p_nwd AREA=1534.63 PJ=156.7 $X=78700 $Y=752075 $D=87
D4 GNDA 13 p_nwd AREA=2572.65 PJ=210 $X=124200 $Y=752075 $D=87
D5 GNDA VDDA p_nwd AREA=38385.2 PJ=784.8 $X=229050 $Y=679650 $D=87
M6 GNDA GNDA GNDA GNDA nmos4 L=4e-05 W=1e-05 AD=8.5e-12 AS=8.5e-12 PD=1.17e-05 PS=1.17e-05 NRD=0.0425 NRS=0.0425 $X=38400 $Y=707500 $D=38
M7 GNDA GNDA GNDA GNDA nmos4 L=4e-05 W=1e-05 AD=8.5e-12 AS=8.5e-12 PD=1.17e-05 PS=1.17e-05 NRD=0.0425 NRS=0.0425 $X=38400 $Y=721900 $D=38
M8 GNDA GNDA GNDA GNDA nmos4 L=5e-07 W=5e-06 AD=4.25e-12 AS=4.25e-12 PD=6.7e-06 PS=6.7e-06 NRD=0.085 NRS=0.085 $X=44250 $Y=762400 $D=38
M9 GNDA GNDA GNDA GNDA nmos4 L=5e-07 W=5e-06 AD=4.25e-12 AS=4.25e-12 PD=6.7e-06 PS=6.7e-06 NRD=0.085 NRS=0.085 $X=44250 $Y=771800 $D=38
M10 GNDA GNDA GNDA GNDA nmos4 L=5e-07 W=5e-06 AD=4.25e-12 AS=4.25e-12 PD=6.7e-06 PS=6.7e-06 NRD=0.085 NRS=0.085 $X=52650 $Y=762400 $D=38
M11 GNDA GNDA GNDA GNDA nmos4 L=5e-07 W=5e-06 AD=4.25e-12 AS=4.25e-12 PD=6.7e-06 PS=6.7e-06 NRD=0.085 NRS=0.085 $X=52650 $Y=771800 $D=38
M12 GNDA GNDA GNDA GNDA nmos4 L=1e-05 W=5e-06 AD=4.25e-12 AS=4.25e-12 PD=6.7e-06 PS=6.7e-06 NRD=0.085 NRS=0.085 $X=83225 $Y=819800 $D=38
M13 GNDA GNDA GNDA GNDA nmos4 L=1e-05 W=5e-06 AD=4.25e-12 AS=4.25e-12 PD=6.7e-06 PS=6.7e-06 NRD=0.085 NRS=0.085 $X=83225 $Y=829200 $D=38
M14 GNDA GNDA GNDA GNDA nmos4 L=1e-05 W=5e-06 AD=4.25e-12 AS=4.25e-12 PD=6.7e-06 PS=6.7e-06 NRD=0.085 NRS=0.085 $X=132425 $Y=819800 $D=38
M15 GNDA GNDA GNDA GNDA nmos4 L=1e-05 W=5e-06 AD=4.25e-12 AS=4.25e-12 PD=6.7e-06 PS=6.7e-06 NRD=0.085 NRS=0.085 $X=132425 $Y=829200 $D=38
M16 GNDA GNDA GNDA GNDA nmos4 L=4e-05 W=1e-05 AD=8.5e-12 AS=8.5e-12 PD=1.17e-05 PS=1.17e-05 NRD=0.0425 NRS=0.0425 $X=165300 $Y=707500 $D=38
M17 GNDA GNDA GNDA GNDA nmos4 L=4e-05 W=1e-05 AD=8.5e-12 AS=8.5e-12 PD=1.17e-05 PS=1.17e-05 NRD=0.0425 NRS=0.0425 $X=165300 $Y=721900 $D=38
M18 GNDA 8 8 GNDA nmos4 L=2.5e-05 W=5e-06 AD=4.25e-12 AS=4.25e-12 PD=6.7e-06 PS=6.7e-06 NRD=0.085 NRS=0.085 $X=32900 $Y=796250 $D=37
M19 GNDA 9 7 GNDA nmos4 L=5e-07 W=5e-06 AD=4.25e-12 AS=4.25e-12 PD=6.7e-06 PS=6.7e-06 NRD=0.085 NRS=0.085 $X=47050 $Y=762400 $D=37
M20 GNDA 9 9 GNDA nmos4 L=5e-07 W=5e-06 AD=4.25e-12 AS=4.25e-12 PD=6.7e-06 PS=6.7e-06 NRD=0.085 NRS=0.085 $X=47050 $Y=771800 $D=37
M21 GNDA 9 9 GNDA nmos4 L=5e-07 W=5e-06 AD=4.25e-12 AS=4.25e-12 PD=6.7e-06 PS=6.7e-06 NRD=0.085 NRS=0.085 $X=49850 $Y=762400 $D=37
M22 GNDA 9 7 GNDA nmos4 L=5e-07 W=5e-06 AD=4.25e-12 AS=4.25e-12 PD=6.7e-06 PS=6.7e-06 NRD=0.085 NRS=0.085 $X=49850 $Y=771800 $D=37
M23 GNDA 6 5 GNDA nmos4 L=4e-05 W=1e-05 AD=8.5e-12 AS=8.5e-12 PD=1.17e-05 PS=1.17e-05 NRD=0.0425 NRS=0.0425 $X=80700 $Y=707500 $D=37
M24 GNDA 6 6 GNDA nmos4 L=4e-05 W=1e-05 AD=8.5e-12 AS=8.5e-12 PD=1.17e-05 PS=1.17e-05 NRD=0.0425 NRS=0.0425 $X=80700 $Y=721900 $D=37
M25 GNDA 17 17 GNDA nmos4 L=1e-05 W=5e-06 AD=4.25e-12 AS=4.25e-12 PD=6.7e-06 PS=6.7e-06 NRD=0.085 NRS=0.085 $X=107825 $Y=819800 $D=37
M26 GNDA 17 17 GNDA nmos4 L=1e-05 W=5e-06 AD=4.25e-12 AS=4.25e-12 PD=6.7e-06 PS=6.7e-06 NRD=0.085 NRS=0.085 $X=107825 $Y=829200 $D=37
M27 GNDA 6 6 GNDA nmos4 L=4e-05 W=1e-05 AD=8.5e-12 AS=8.5e-12 PD=1.17e-05 PS=1.17e-05 NRD=0.0425 NRS=0.0425 $X=123000 $Y=707500 $D=37
M28 GNDA 6 5 GNDA nmos4 L=4e-05 W=1e-05 AD=8.5e-12 AS=8.5e-12 PD=1.17e-05 PS=1.17e-05 NRD=0.0425 NRS=0.0425 $X=123000 $Y=721900 $D=37
M29 GNDA 5 19 GNDA nmos4 L=5e-06 W=2e-05 AD=1.7e-11 AS=1.7e-11 PD=2.17e-05 PS=2.17e-05 NRD=0.02125 NRS=0.02125 $X=187350 $Y=804900 $D=37
M30 BG_REF 7 19 GNDA nmos4 L=1e-05 W=5e-06 AD=4.25e-12 AS=4.25e-12 PD=6.7e-06 PS=6.7e-06 NRD=0.085 NRS=0.085 $X=199650 $Y=821300 $D=37
M31 10 10 10 10 pmos4 L=5e-07 W=5e-06 AD=4.25e-12 AS=4.25e-12 PD=6.7e-06 PS=6.7e-06 NRD=0.085 NRS=0.085 $X=93925 $Y=763500 $D=42
M32 10 10 10 10 pmos4 L=5e-07 W=5e-06 AD=4.25e-12 AS=4.25e-12 PD=6.7e-06 PS=6.7e-06 NRD=0.085 NRS=0.085 $X=93925 $Y=774650 $D=42
M33 10 10 10 10 pmos4 L=5e-07 W=5e-06 AD=4.25e-12 AS=4.25e-12 PD=6.7e-06 PS=6.7e-06 NRD=0.085 NRS=0.085 $X=102325 $Y=763500 $D=42
M34 10 10 10 10 pmos4 L=5e-07 W=5e-06 AD=4.25e-12 AS=4.25e-12 PD=6.7e-06 PS=6.7e-06 NRD=0.085 NRS=0.085 $X=102325 $Y=774650 $D=42
M35 13 13 13 13 pmos4 L=4e-06 W=5e-06 AD=4.25e-12 AS=4.25e-12 PD=6.7e-06 PS=6.7e-06 NRD=0.085 NRS=0.085 $X=139475 $Y=763500 $D=42
M36 13 13 13 13 pmos4 L=4e-06 W=5e-06 AD=4.25e-12 AS=4.25e-12 PD=6.7e-06 PS=6.7e-06 NRD=0.085 NRS=0.085 $X=139475 $Y=774650 $D=42
M37 13 13 13 13 pmos4 L=4e-06 W=5e-06 AD=4.25e-12 AS=4.25e-12 PD=6.7e-06 PS=6.7e-06 NRD=0.085 NRS=0.085 $X=170975 $Y=763500 $D=42
M38 13 13 13 13 pmos4 L=4e-06 W=5e-06 AD=4.25e-12 AS=4.25e-12 PD=6.7e-06 PS=6.7e-06 NRD=0.085 NRS=0.085 $X=170975 $Y=774650 $D=42
M39 VDDA VDDA VDDA VDDA pmos4 L=1e-05 W=5e-06 AD=4.25e-12 AS=4.25e-12 PD=6.7e-06 PS=6.7e-06 NRD=0.085 NRS=0.085 $X=193825 $Y=858950 $D=42
M40 VDDA VDDA VDDA VDDA pmos4 L=1e-05 W=5e-06 AD=4.25e-12 AS=4.25e-12 PD=6.7e-06 PS=6.7e-06 NRD=0.085 NRS=0.085 $X=193825 $Y=869950 $D=42
M41 VDDA VDDA VDDA VDDA pmos4 L=1e-05 W=5e-06 AD=4.25e-12 AS=4.25e-12 PD=6.7e-06 PS=6.7e-06 NRD=0.085 NRS=0.085 $X=261625 $Y=686950 $D=42
M42 VDDA VDDA VDDA VDDA pmos4 L=1e-05 W=5e-06 AD=4.25e-12 AS=4.25e-12 PD=6.7e-06 PS=6.7e-06 NRD=0.085 NRS=0.085 $X=261625 $Y=705650 $D=42
M43 VDDA VDDA VDDA VDDA pmos4 L=1e-05 W=5e-06 AD=4.25e-12 AS=4.25e-12 PD=6.7e-06 PS=6.7e-06 NRD=0.085 NRS=0.085 $X=261625 $Y=724350 $D=42
M44 VDDA VDDA VDDA VDDA pmos4 L=1e-05 W=5e-06 AD=4.25e-12 AS=4.25e-12 PD=6.7e-06 PS=6.7e-06 NRD=0.085 NRS=0.085 $X=261625 $Y=836550 $D=42
M45 VDDA VDDA VDDA VDDA pmos4 L=1e-05 W=5e-06 AD=4.25e-12 AS=4.25e-12 PD=6.7e-06 PS=6.7e-06 NRD=0.085 NRS=0.085 $X=261625 $Y=855250 $D=42
M46 VDDA VDDA VDDA VDDA pmos4 L=1e-05 W=5e-06 AD=4.25e-12 AS=4.25e-12 PD=6.7e-06 PS=6.7e-06 NRD=0.085 NRS=0.085 $X=261625 $Y=873950 $D=42
M47 VDDA VDDA VDDA VDDA pmos4 L=1e-05 W=5e-06 AD=4.25e-12 AS=4.25e-12 PD=6.7e-06 PS=6.7e-06 NRD=0.085 NRS=0.085 $X=273925 $Y=686950 $D=42
M48 VDDA VDDA VDDA VDDA pmos4 L=1e-05 W=5e-06 AD=4.25e-12 AS=4.25e-12 PD=6.7e-06 PS=6.7e-06 NRD=0.085 NRS=0.085 $X=273925 $Y=873950 $D=42
M49 VDDA VDDA VDDA VDDA pmos4 L=1e-05 W=5e-06 AD=4.25e-12 AS=4.25e-12 PD=6.7e-06 PS=6.7e-06 NRD=0.085 NRS=0.085 $X=286225 $Y=686950 $D=42
M50 VDDA VDDA VDDA VDDA pmos4 L=1e-05 W=5e-06 AD=4.25e-12 AS=4.25e-12 PD=6.7e-06 PS=6.7e-06 NRD=0.085 NRS=0.085 $X=286225 $Y=873950 $D=42
M51 VDDA VDDA VDDA VDDA pmos4 L=1e-05 W=5e-06 AD=4.25e-12 AS=4.25e-12 PD=6.7e-06 PS=6.7e-06 NRD=0.085 NRS=0.085 $X=298525 $Y=686950 $D=42
M52 VDDA VDDA VDDA VDDA pmos4 L=1e-05 W=5e-06 AD=4.25e-12 AS=4.25e-12 PD=6.7e-06 PS=6.7e-06 NRD=0.085 NRS=0.085 $X=298525 $Y=873950 $D=42
M53 VDDA VDDA VDDA VDDA pmos4 L=1e-05 W=5e-06 AD=4.25e-12 AS=4.25e-12 PD=6.7e-06 PS=6.7e-06 NRD=0.085 NRS=0.085 $X=310825 $Y=686950 $D=42
M54 VDDA VDDA VDDA VDDA pmos4 L=1e-05 W=5e-06 AD=4.25e-12 AS=4.25e-12 PD=6.7e-06 PS=6.7e-06 NRD=0.085 NRS=0.085 $X=310825 $Y=873950 $D=42
M55 VDDA VDDA VDDA VDDA pmos4 L=1e-05 W=5e-06 AD=4.25e-12 AS=4.25e-12 PD=6.7e-06 PS=6.7e-06 NRD=0.085 NRS=0.085 $X=323125 $Y=686950 $D=42
M56 VDDA VDDA VDDA VDDA pmos4 L=1e-05 W=5e-06 AD=4.25e-12 AS=4.25e-12 PD=6.7e-06 PS=6.7e-06 NRD=0.085 NRS=0.085 $X=323125 $Y=873950 $D=42
M57 VDDA VDDA VDDA VDDA pmos4 L=1e-05 W=5e-06 AD=4.25e-12 AS=4.25e-12 PD=6.7e-06 PS=6.7e-06 NRD=0.085 NRS=0.085 $X=335425 $Y=686950 $D=42
M58 VDDA VDDA VDDA VDDA pmos4 L=1e-05 W=5e-06 AD=4.25e-12 AS=4.25e-12 PD=6.7e-06 PS=6.7e-06 NRD=0.085 NRS=0.085 $X=335425 $Y=873950 $D=42
M59 VDDA VDDA VDDA VDDA pmos4 L=1e-05 W=5e-06 AD=4.25e-12 AS=4.25e-12 PD=6.7e-06 PS=6.7e-06 NRD=0.085 NRS=0.085 $X=347725 $Y=686950 $D=42
M60 VDDA VDDA VDDA VDDA pmos4 L=1e-05 W=5e-06 AD=4.25e-12 AS=4.25e-12 PD=6.7e-06 PS=6.7e-06 NRD=0.085 NRS=0.085 $X=347725 $Y=873950 $D=42
M61 VDDA VDDA VDDA VDDA pmos4 L=1e-05 W=5e-06 AD=4.25e-12 AS=4.25e-12 PD=6.7e-06 PS=6.7e-06 NRD=0.085 NRS=0.085 $X=360025 $Y=686950 $D=42
M62 VDDA VDDA VDDA VDDA pmos4 L=1e-05 W=5e-06 AD=4.25e-12 AS=4.25e-12 PD=6.7e-06 PS=6.7e-06 NRD=0.085 NRS=0.085 $X=360025 $Y=873950 $D=42
M63 VDDA VDDA VDDA VDDA pmos4 L=1e-05 W=5e-06 AD=4.25e-12 AS=4.25e-12 PD=6.7e-06 PS=6.7e-06 NRD=0.085 NRS=0.085 $X=372325 $Y=686950 $D=42
M64 VDDA VDDA VDDA VDDA pmos4 L=1e-05 W=5e-06 AD=4.25e-12 AS=4.25e-12 PD=6.7e-06 PS=6.7e-06 NRD=0.085 NRS=0.085 $X=372325 $Y=705650 $D=42
M65 VDDA VDDA VDDA VDDA pmos4 L=1e-05 W=5e-06 AD=4.25e-12 AS=4.25e-12 PD=6.7e-06 PS=6.7e-06 NRD=0.085 NRS=0.085 $X=372325 $Y=724350 $D=42
M66 VDDA VDDA VDDA VDDA pmos4 L=1e-05 W=5e-06 AD=4.25e-12 AS=4.25e-12 PD=6.7e-06 PS=6.7e-06 NRD=0.085 NRS=0.085 $X=372325 $Y=836550 $D=42
M67 VDDA VDDA VDDA VDDA pmos4 L=1e-05 W=5e-06 AD=4.25e-12 AS=4.25e-12 PD=6.7e-06 PS=6.7e-06 NRD=0.085 NRS=0.085 $X=372325 $Y=855250 $D=42
M68 VDDA VDDA VDDA VDDA pmos4 L=1e-05 W=5e-06 AD=4.25e-12 AS=4.25e-12 PD=6.7e-06 PS=6.7e-06 NRD=0.085 NRS=0.085 $X=372325 $Y=873950 $D=42
M69 VDDA VDDA VDDA VDDA pmos4 L=1e-05 W=5e-06 AD=4.25e-12 AS=4.25e-12 PD=6.7e-06 PS=6.7e-06 NRD=0.085 NRS=0.085 $X=384625 $Y=686950 $D=42
M70 VDDA VDDA VDDA VDDA pmos4 L=1e-05 W=5e-06 AD=4.25e-12 AS=4.25e-12 PD=6.7e-06 PS=6.7e-06 NRD=0.085 NRS=0.085 $X=384625 $Y=705650 $D=42
M71 VDDA VDDA VDDA VDDA pmos4 L=1e-05 W=5e-06 AD=4.25e-12 AS=4.25e-12 PD=6.7e-06 PS=6.7e-06 NRD=0.085 NRS=0.085 $X=384625 $Y=724350 $D=42
M72 VDDA VDDA VDDA VDDA pmos4 L=1e-05 W=5e-06 AD=4.25e-12 AS=4.25e-12 PD=6.7e-06 PS=6.7e-06 NRD=0.085 NRS=0.085 $X=384625 $Y=743050 $D=42
M73 VDDA VDDA VDDA VDDA pmos4 L=1e-05 W=5e-06 AD=4.25e-12 AS=4.25e-12 PD=6.7e-06 PS=6.7e-06 NRD=0.085 NRS=0.085 $X=384625 $Y=761750 $D=42
M74 VDDA VDDA VDDA VDDA pmos4 L=1e-05 W=5e-06 AD=4.25e-12 AS=4.25e-12 PD=6.7e-06 PS=6.7e-06 NRD=0.085 NRS=0.085 $X=384625 $Y=780450 $D=42
M75 VDDA VDDA VDDA VDDA pmos4 L=1e-05 W=5e-06 AD=4.25e-12 AS=4.25e-12 PD=6.7e-06 PS=6.7e-06 NRD=0.085 NRS=0.085 $X=384625 $Y=799150 $D=42
M76 VDDA VDDA VDDA VDDA pmos4 L=1e-05 W=5e-06 AD=4.25e-12 AS=4.25e-12 PD=6.7e-06 PS=6.7e-06 NRD=0.085 NRS=0.085 $X=384625 $Y=817850 $D=42
M77 VDDA VDDA VDDA VDDA pmos4 L=1e-05 W=5e-06 AD=4.25e-12 AS=4.25e-12 PD=6.7e-06 PS=6.7e-06 NRD=0.085 NRS=0.085 $X=384625 $Y=836550 $D=42
M78 VDDA VDDA VDDA VDDA pmos4 L=1e-05 W=5e-06 AD=4.25e-12 AS=4.25e-12 PD=6.7e-06 PS=6.7e-06 NRD=0.085 NRS=0.085 $X=384625 $Y=855250 $D=42
M79 VDDA VDDA VDDA VDDA pmos4 L=1e-05 W=5e-06 AD=4.25e-12 AS=4.25e-12 PD=6.7e-06 PS=6.7e-06 NRD=0.085 NRS=0.085 $X=384625 $Y=873950 $D=42
M80 VDDA 16 10 VDDA pmos4 L=1e-05 W=5e-06 AD=4.25e-12 AS=4.25e-12 PD=6.7e-06 PS=6.7e-06 NRD=0.085 NRS=0.085 $X=58525 $Y=858950 $D=41
M81 VDDA 16 8 VDDA pmos4 L=1e-05 W=5e-06 AD=4.25e-12 AS=4.25e-12 PD=6.7e-06 PS=6.7e-06 NRD=0.085 NRS=0.085 $X=58525 $Y=869950 $D=41
M82 VDDA 16 8 VDDA pmos4 L=1e-05 W=5e-06 AD=4.25e-12 AS=4.25e-12 PD=6.7e-06 PS=6.7e-06 NRD=0.085 NRS=0.085 $X=70825 $Y=858950 $D=41
M83 VDDA 16 10 VDDA pmos4 L=1e-05 W=5e-06 AD=4.25e-12 AS=4.25e-12 PD=6.7e-06 PS=6.7e-06 NRD=0.085 NRS=0.085 $X=70825 $Y=869950 $D=41
M84 VDDA 16 10 VDDA pmos4 L=1e-05 W=5e-06 AD=4.25e-12 AS=4.25e-12 PD=6.7e-06 PS=6.7e-06 NRD=0.085 NRS=0.085 $X=83125 $Y=858950 $D=41
M85 VDDA 16 8 VDDA pmos4 L=1e-05 W=5e-06 AD=4.25e-12 AS=4.25e-12 PD=6.7e-06 PS=6.7e-06 NRD=0.085 NRS=0.085 $X=83125 $Y=869950 $D=41
M86 VDDA 16 8 VDDA pmos4 L=1e-05 W=5e-06 AD=4.25e-12 AS=4.25e-12 PD=6.7e-06 PS=6.7e-06 NRD=0.085 NRS=0.085 $X=95425 $Y=858950 $D=41
M87 VDDA 16 10 VDDA pmos4 L=1e-05 W=5e-06 AD=4.25e-12 AS=4.25e-12 PD=6.7e-06 PS=6.7e-06 NRD=0.085 NRS=0.085 $X=95425 $Y=869950 $D=41
M88 10 8 7 10 pmos4 L=5e-07 W=5e-06 AD=4.25e-12 AS=4.25e-12 PD=6.7e-06 PS=6.7e-06 NRD=0.085 NRS=0.085 $X=96725 $Y=763500 $D=41
M89 10 BG_REF 9 10 pmos4 L=5e-07 W=5e-06 AD=4.25e-12 AS=4.25e-12 PD=6.7e-06 PS=6.7e-06 NRD=0.085 NRS=0.085 $X=96725 $Y=774650 $D=41
M90 10 BG_REF 9 10 pmos4 L=5e-07 W=5e-06 AD=4.25e-12 AS=4.25e-12 PD=6.7e-06 PS=6.7e-06 NRD=0.085 NRS=0.085 $X=99525 $Y=763500 $D=41
M91 10 8 7 10 pmos4 L=5e-07 W=5e-06 AD=4.25e-12 AS=4.25e-12 PD=6.7e-06 PS=6.7e-06 NRD=0.085 NRS=0.085 $X=99525 $Y=774650 $D=41
M92 VDDA 16 10 VDDA pmos4 L=1e-05 W=5e-06 AD=4.25e-12 AS=4.25e-12 PD=6.7e-06 PS=6.7e-06 NRD=0.085 NRS=0.085 $X=107725 $Y=858950 $D=41
M93 VDDA 16 8 VDDA pmos4 L=1e-05 W=5e-06 AD=4.25e-12 AS=4.25e-12 PD=6.7e-06 PS=6.7e-06 NRD=0.085 NRS=0.085 $X=107725 $Y=869950 $D=41
M94 VDDA 16 16 VDDA pmos4 L=1e-05 W=5e-06 AD=4.25e-12 AS=4.25e-12 PD=6.7e-06 PS=6.7e-06 NRD=0.085 NRS=0.085 $X=120025 $Y=858950 $D=41
M95 VDDA 16 16 VDDA pmos4 L=1e-05 W=5e-06 AD=4.25e-12 AS=4.25e-12 PD=6.7e-06 PS=6.7e-06 NRD=0.085 NRS=0.085 $X=120025 $Y=869950 $D=41
M96 VDDA 16 10 VDDA pmos4 L=1e-05 W=5e-06 AD=4.25e-12 AS=4.25e-12 PD=6.7e-06 PS=6.7e-06 NRD=0.085 NRS=0.085 $X=132325 $Y=858950 $D=41
M97 VDDA 16 8 VDDA pmos4 L=1e-05 W=5e-06 AD=4.25e-12 AS=4.25e-12 PD=6.7e-06 PS=6.7e-06 NRD=0.085 NRS=0.085 $X=132325 $Y=869950 $D=41
M98 VDDA 16 8 VDDA pmos4 L=1e-05 W=5e-06 AD=4.25e-12 AS=4.25e-12 PD=6.7e-06 PS=6.7e-06 NRD=0.085 NRS=0.085 $X=144625 $Y=858950 $D=41
M99 VDDA 16 10 VDDA pmos4 L=1e-05 W=5e-06 AD=4.25e-12 AS=4.25e-12 PD=6.7e-06 PS=6.7e-06 NRD=0.085 NRS=0.085 $X=144625 $Y=869950 $D=41
M100 13 21 5 13 pmos4 L=4e-06 W=5e-06 AD=4.25e-12 AS=4.25e-12 PD=6.7e-06 PS=6.7e-06 NRD=0.085 NRS=0.085 $X=145775 $Y=763500 $D=41
M101 13 20 6 13 pmos4 L=4e-06 W=5e-06 AD=4.25e-12 AS=4.25e-12 PD=6.7e-06 PS=6.7e-06 NRD=0.085 NRS=0.085 $X=145775 $Y=774650 $D=41
M102 13 20 6 13 pmos4 L=4e-06 W=5e-06 AD=4.25e-12 AS=4.25e-12 PD=6.7e-06 PS=6.7e-06 NRD=0.085 NRS=0.085 $X=152075 $Y=763500 $D=41
M103 13 21 5 13 pmos4 L=4e-06 W=5e-06 AD=4.25e-12 AS=4.25e-12 PD=6.7e-06 PS=6.7e-06 NRD=0.085 NRS=0.085 $X=152075 $Y=774650 $D=41
M104 VDDA 16 10 VDDA pmos4 L=1e-05 W=5e-06 AD=4.25e-12 AS=4.25e-12 PD=6.7e-06 PS=6.7e-06 NRD=0.085 NRS=0.085 $X=156925 $Y=858950 $D=41
M105 VDDA 16 8 VDDA pmos4 L=1e-05 W=5e-06 AD=4.25e-12 AS=4.25e-12 PD=6.7e-06 PS=6.7e-06 NRD=0.085 NRS=0.085 $X=156925 $Y=869950 $D=41
M106 13 20 6 13 pmos4 L=4e-06 W=5e-06 AD=4.25e-12 AS=4.25e-12 PD=6.7e-06 PS=6.7e-06 NRD=0.085 NRS=0.085 $X=158375 $Y=763500 $D=41
M107 13 21 5 13 pmos4 L=4e-06 W=5e-06 AD=4.25e-12 AS=4.25e-12 PD=6.7e-06 PS=6.7e-06 NRD=0.085 NRS=0.085 $X=158375 $Y=774650 $D=41
M108 13 21 5 13 pmos4 L=4e-06 W=5e-06 AD=4.25e-12 AS=4.25e-12 PD=6.7e-06 PS=6.7e-06 NRD=0.085 NRS=0.085 $X=164675 $Y=763500 $D=41
M109 13 20 6 13 pmos4 L=4e-06 W=5e-06 AD=4.25e-12 AS=4.25e-12 PD=6.7e-06 PS=6.7e-06 NRD=0.085 NRS=0.085 $X=164675 $Y=774650 $D=41
M110 VDDA 16 8 VDDA pmos4 L=1e-05 W=5e-06 AD=4.25e-12 AS=4.25e-12 PD=6.7e-06 PS=6.7e-06 NRD=0.085 NRS=0.085 $X=169225 $Y=858950 $D=41
M111 VDDA 16 10 VDDA pmos4 L=1e-05 W=5e-06 AD=4.25e-12 AS=4.25e-12 PD=6.7e-06 PS=6.7e-06 NRD=0.085 NRS=0.085 $X=169225 $Y=869950 $D=41
M112 VDDA 16 10 VDDA pmos4 L=1e-05 W=5e-06 AD=4.25e-12 AS=4.25e-12 PD=6.7e-06 PS=6.7e-06 NRD=0.085 NRS=0.085 $X=181525 $Y=858950 $D=41
M113 VDDA 16 8 VDDA pmos4 L=1e-05 W=5e-06 AD=4.25e-12 AS=4.25e-12 PD=6.7e-06 PS=6.7e-06 NRD=0.085 NRS=0.085 $X=181525 $Y=869950 $D=41
M114 VDDA 14 BG_REF VDDA pmos4 L=1e-05 W=5e-06 AD=4.25e-12 AS=4.25e-12 PD=6.7e-06 PS=6.7e-06 NRD=0.085 NRS=0.085 $X=261625 $Y=743050 $D=41
M115 VDDA 14 BG_REF VDDA pmos4 L=1e-05 W=5e-06 AD=4.25e-12 AS=4.25e-12 PD=6.7e-06 PS=6.7e-06 NRD=0.085 NRS=0.085 $X=261625 $Y=761750 $D=41
M116 VDDA 14 13 VDDA pmos4 L=1e-05 W=5e-06 AD=4.25e-12 AS=4.25e-12 PD=6.7e-06 PS=6.7e-06 NRD=0.085 NRS=0.085 $X=261625 $Y=780450 $D=41
M117 VDDA 14 BG_REF VDDA pmos4 L=1e-05 W=5e-06 AD=4.25e-12 AS=4.25e-12 PD=6.7e-06 PS=6.7e-06 NRD=0.085 NRS=0.085 $X=261625 $Y=799150 $D=41
M118 VDDA 14 BG_REF VDDA pmos4 L=1e-05 W=5e-06 AD=4.25e-12 AS=4.25e-12 PD=6.7e-06 PS=6.7e-06 NRD=0.085 NRS=0.085 $X=261625 $Y=817850 $D=41
M119 VDDA 14 13 VDDA pmos4 L=1e-05 W=5e-06 AD=4.25e-12 AS=4.25e-12 PD=6.7e-06 PS=6.7e-06 NRD=0.085 NRS=0.085 $X=273925 $Y=705650 $D=41
M120 VDDA 14 BG_REF VDDA pmos4 L=1e-05 W=5e-06 AD=4.25e-12 AS=4.25e-12 PD=6.7e-06 PS=6.7e-06 NRD=0.085 NRS=0.085 $X=273925 $Y=724350 $D=41
M121 VDDA 14 BG_REF VDDA pmos4 L=1e-05 W=5e-06 AD=4.25e-12 AS=4.25e-12 PD=6.7e-06 PS=6.7e-06 NRD=0.085 NRS=0.085 $X=273925 $Y=743050 $D=41
M122 VDDA 14 BG_REF VDDA pmos4 L=1e-05 W=5e-06 AD=4.25e-12 AS=4.25e-12 PD=6.7e-06 PS=6.7e-06 NRD=0.085 NRS=0.085 $X=273925 $Y=761750 $D=41
M123 VDDA 14 BG_REF VDDA pmos4 L=1e-05 W=5e-06 AD=4.25e-12 AS=4.25e-12 PD=6.7e-06 PS=6.7e-06 NRD=0.085 NRS=0.085 $X=273925 $Y=780450 $D=41
M124 VDDA 14 BG_REF VDDA pmos4 L=1e-05 W=5e-06 AD=4.25e-12 AS=4.25e-12 PD=6.7e-06 PS=6.7e-06 NRD=0.085 NRS=0.085 $X=273925 $Y=799150 $D=41
M125 VDDA 14 BG_REF VDDA pmos4 L=1e-05 W=5e-06 AD=4.25e-12 AS=4.25e-12 PD=6.7e-06 PS=6.7e-06 NRD=0.085 NRS=0.085 $X=273925 $Y=817850 $D=41
M126 VDDA 14 BG_REF VDDA pmos4 L=1e-05 W=5e-06 AD=4.25e-12 AS=4.25e-12 PD=6.7e-06 PS=6.7e-06 NRD=0.085 NRS=0.085 $X=273925 $Y=836550 $D=41
M127 VDDA 14 13 VDDA pmos4 L=1e-05 W=5e-06 AD=4.25e-12 AS=4.25e-12 PD=6.7e-06 PS=6.7e-06 NRD=0.085 NRS=0.085 $X=273925 $Y=855250 $D=41
M128 VDDA 14 BG_REF VDDA pmos4 L=1e-05 W=5e-06 AD=4.25e-12 AS=4.25e-12 PD=6.7e-06 PS=6.7e-06 NRD=0.085 NRS=0.085 $X=286225 $Y=705650 $D=41
M129 VDDA 14 13 VDDA pmos4 L=1e-05 W=5e-06 AD=4.25e-12 AS=4.25e-12 PD=6.7e-06 PS=6.7e-06 NRD=0.085 NRS=0.085 $X=286225 $Y=724350 $D=41
M130 VDDA 14 BG_REF VDDA pmos4 L=1e-05 W=5e-06 AD=4.25e-12 AS=4.25e-12 PD=6.7e-06 PS=6.7e-06 NRD=0.085 NRS=0.085 $X=286225 $Y=743050 $D=41
M131 VDDA 14 BG_REF VDDA pmos4 L=1e-05 W=5e-06 AD=4.25e-12 AS=4.25e-12 PD=6.7e-06 PS=6.7e-06 NRD=0.085 NRS=0.085 $X=286225 $Y=761750 $D=41
M132 VDDA 14 13 VDDA pmos4 L=1e-05 W=5e-06 AD=4.25e-12 AS=4.25e-12 PD=6.7e-06 PS=6.7e-06 NRD=0.085 NRS=0.085 $X=286225 $Y=780450 $D=41
M133 VDDA 14 BG_REF VDDA pmos4 L=1e-05 W=5e-06 AD=4.25e-12 AS=4.25e-12 PD=6.7e-06 PS=6.7e-06 NRD=0.085 NRS=0.085 $X=286225 $Y=799150 $D=41
M134 VDDA 14 BG_REF VDDA pmos4 L=1e-05 W=5e-06 AD=4.25e-12 AS=4.25e-12 PD=6.7e-06 PS=6.7e-06 NRD=0.085 NRS=0.085 $X=286225 $Y=817850 $D=41
M135 VDDA 14 13 VDDA pmos4 L=1e-05 W=5e-06 AD=4.25e-12 AS=4.25e-12 PD=6.7e-06 PS=6.7e-06 NRD=0.085 NRS=0.085 $X=286225 $Y=836550 $D=41
M136 VDDA 14 BG_REF VDDA pmos4 L=1e-05 W=5e-06 AD=4.25e-12 AS=4.25e-12 PD=6.7e-06 PS=6.7e-06 NRD=0.085 NRS=0.085 $X=286225 $Y=855250 $D=41
M137 VDDA 14 BG_REF VDDA pmos4 L=1e-05 W=5e-06 AD=4.25e-12 AS=4.25e-12 PD=6.7e-06 PS=6.7e-06 NRD=0.085 NRS=0.085 $X=298525 $Y=705650 $D=41
M138 VDDA 14 BG_REF VDDA pmos4 L=1e-05 W=5e-06 AD=4.25e-12 AS=4.25e-12 PD=6.7e-06 PS=6.7e-06 NRD=0.085 NRS=0.085 $X=298525 $Y=724350 $D=41
M139 VDDA 14 13 VDDA pmos4 L=1e-05 W=5e-06 AD=4.25e-12 AS=4.25e-12 PD=6.7e-06 PS=6.7e-06 NRD=0.085 NRS=0.085 $X=298525 $Y=743050 $D=41
M140 VDDA 14 BG_REF VDDA pmos4 L=1e-05 W=5e-06 AD=4.25e-12 AS=4.25e-12 PD=6.7e-06 PS=6.7e-06 NRD=0.085 NRS=0.085 $X=298525 $Y=761750 $D=41
M141 VDDA 14 BG_REF VDDA pmos4 L=1e-05 W=5e-06 AD=4.25e-12 AS=4.25e-12 PD=6.7e-06 PS=6.7e-06 NRD=0.085 NRS=0.085 $X=298525 $Y=780450 $D=41
M142 VDDA 14 BG_REF VDDA pmos4 L=1e-05 W=5e-06 AD=4.25e-12 AS=4.25e-12 PD=6.7e-06 PS=6.7e-06 NRD=0.085 NRS=0.085 $X=298525 $Y=799150 $D=41
M143 VDDA 14 13 VDDA pmos4 L=1e-05 W=5e-06 AD=4.25e-12 AS=4.25e-12 PD=6.7e-06 PS=6.7e-06 NRD=0.085 NRS=0.085 $X=298525 $Y=817850 $D=41
M144 VDDA 14 BG_REF VDDA pmos4 L=1e-05 W=5e-06 AD=4.25e-12 AS=4.25e-12 PD=6.7e-06 PS=6.7e-06 NRD=0.085 NRS=0.085 $X=298525 $Y=836550 $D=41
M145 VDDA 14 BG_REF VDDA pmos4 L=1e-05 W=5e-06 AD=4.25e-12 AS=4.25e-12 PD=6.7e-06 PS=6.7e-06 NRD=0.085 NRS=0.085 $X=298525 $Y=855250 $D=41
M146 VDDA 14 BG_REF VDDA pmos4 L=1e-05 W=5e-06 AD=4.25e-12 AS=4.25e-12 PD=6.7e-06 PS=6.7e-06 NRD=0.085 NRS=0.085 $X=310825 $Y=705650 $D=41
M147 VDDA 14 BG_REF VDDA pmos4 L=1e-05 W=5e-06 AD=4.25e-12 AS=4.25e-12 PD=6.7e-06 PS=6.7e-06 NRD=0.085 NRS=0.085 $X=310825 $Y=724350 $D=41
M148 VDDA 14 BG_REF VDDA pmos4 L=1e-05 W=5e-06 AD=4.25e-12 AS=4.25e-12 PD=6.7e-06 PS=6.7e-06 NRD=0.085 NRS=0.085 $X=310825 $Y=743050 $D=41
M149 VDDA 14 13 VDDA pmos4 L=1e-05 W=5e-06 AD=4.25e-12 AS=4.25e-12 PD=6.7e-06 PS=6.7e-06 NRD=0.085 NRS=0.085 $X=310825 $Y=761750 $D=41
M150 VDDA 14 14 VDDA pmos4 L=1e-05 W=5e-06 AD=4.25e-12 AS=4.25e-12 PD=6.7e-06 PS=6.7e-06 NRD=0.085 NRS=0.085 $X=310825 $Y=780450 $D=41
M151 VDDA 14 13 VDDA pmos4 L=1e-05 W=5e-06 AD=4.25e-12 AS=4.25e-12 PD=6.7e-06 PS=6.7e-06 NRD=0.085 NRS=0.085 $X=310825 $Y=799150 $D=41
M152 VDDA 14 BG_REF VDDA pmos4 L=1e-05 W=5e-06 AD=4.25e-12 AS=4.25e-12 PD=6.7e-06 PS=6.7e-06 NRD=0.085 NRS=0.085 $X=310825 $Y=817850 $D=41
M153 VDDA 14 BG_REF VDDA pmos4 L=1e-05 W=5e-06 AD=4.25e-12 AS=4.25e-12 PD=6.7e-06 PS=6.7e-06 NRD=0.085 NRS=0.085 $X=310825 $Y=836550 $D=41
M154 VDDA 14 BG_REF VDDA pmos4 L=1e-05 W=5e-06 AD=4.25e-12 AS=4.25e-12 PD=6.7e-06 PS=6.7e-06 NRD=0.085 NRS=0.085 $X=310825 $Y=855250 $D=41
M155 VDDA 14 BG_REF VDDA pmos4 L=1e-05 W=5e-06 AD=4.25e-12 AS=4.25e-12 PD=6.7e-06 PS=6.7e-06 NRD=0.085 NRS=0.085 $X=323125 $Y=705650 $D=41
M156 VDDA 14 BG_REF VDDA pmos4 L=1e-05 W=5e-06 AD=4.25e-12 AS=4.25e-12 PD=6.7e-06 PS=6.7e-06 NRD=0.085 NRS=0.085 $X=323125 $Y=724350 $D=41
M157 VDDA 14 BG_REF VDDA pmos4 L=1e-05 W=5e-06 AD=4.25e-12 AS=4.25e-12 PD=6.7e-06 PS=6.7e-06 NRD=0.085 NRS=0.085 $X=323125 $Y=743050 $D=41
M158 VDDA 14 13 VDDA pmos4 L=1e-05 W=5e-06 AD=4.25e-12 AS=4.25e-12 PD=6.7e-06 PS=6.7e-06 NRD=0.085 NRS=0.085 $X=323125 $Y=761750 $D=41
M159 VDDA 14 14 VDDA pmos4 L=1e-05 W=5e-06 AD=4.25e-12 AS=4.25e-12 PD=6.7e-06 PS=6.7e-06 NRD=0.085 NRS=0.085 $X=323125 $Y=780450 $D=41
M160 VDDA 14 13 VDDA pmos4 L=1e-05 W=5e-06 AD=4.25e-12 AS=4.25e-12 PD=6.7e-06 PS=6.7e-06 NRD=0.085 NRS=0.085 $X=323125 $Y=799150 $D=41
M161 VDDA 14 BG_REF VDDA pmos4 L=1e-05 W=5e-06 AD=4.25e-12 AS=4.25e-12 PD=6.7e-06 PS=6.7e-06 NRD=0.085 NRS=0.085 $X=323125 $Y=817850 $D=41
M162 VDDA 14 BG_REF VDDA pmos4 L=1e-05 W=5e-06 AD=4.25e-12 AS=4.25e-12 PD=6.7e-06 PS=6.7e-06 NRD=0.085 NRS=0.085 $X=323125 $Y=836550 $D=41
M163 VDDA 14 BG_REF VDDA pmos4 L=1e-05 W=5e-06 AD=4.25e-12 AS=4.25e-12 PD=6.7e-06 PS=6.7e-06 NRD=0.085 NRS=0.085 $X=323125 $Y=855250 $D=41
M164 VDDA 14 BG_REF VDDA pmos4 L=1e-05 W=5e-06 AD=4.25e-12 AS=4.25e-12 PD=6.7e-06 PS=6.7e-06 NRD=0.085 NRS=0.085 $X=335425 $Y=705650 $D=41
M165 VDDA 14 BG_REF VDDA pmos4 L=1e-05 W=5e-06 AD=4.25e-12 AS=4.25e-12 PD=6.7e-06 PS=6.7e-06 NRD=0.085 NRS=0.085 $X=335425 $Y=724350 $D=41
M166 VDDA 14 13 VDDA pmos4 L=1e-05 W=5e-06 AD=4.25e-12 AS=4.25e-12 PD=6.7e-06 PS=6.7e-06 NRD=0.085 NRS=0.085 $X=335425 $Y=743050 $D=41
M167 VDDA 14 BG_REF VDDA pmos4 L=1e-05 W=5e-06 AD=4.25e-12 AS=4.25e-12 PD=6.7e-06 PS=6.7e-06 NRD=0.085 NRS=0.085 $X=335425 $Y=761750 $D=41
M168 VDDA 14 BG_REF VDDA pmos4 L=1e-05 W=5e-06 AD=4.25e-12 AS=4.25e-12 PD=6.7e-06 PS=6.7e-06 NRD=0.085 NRS=0.085 $X=335425 $Y=780450 $D=41
M169 VDDA 14 BG_REF VDDA pmos4 L=1e-05 W=5e-06 AD=4.25e-12 AS=4.25e-12 PD=6.7e-06 PS=6.7e-06 NRD=0.085 NRS=0.085 $X=335425 $Y=799150 $D=41
M170 VDDA 14 13 VDDA pmos4 L=1e-05 W=5e-06 AD=4.25e-12 AS=4.25e-12 PD=6.7e-06 PS=6.7e-06 NRD=0.085 NRS=0.085 $X=335425 $Y=817850 $D=41
M171 VDDA 14 BG_REF VDDA pmos4 L=1e-05 W=5e-06 AD=4.25e-12 AS=4.25e-12 PD=6.7e-06 PS=6.7e-06 NRD=0.085 NRS=0.085 $X=335425 $Y=836550 $D=41
M172 VDDA 14 BG_REF VDDA pmos4 L=1e-05 W=5e-06 AD=4.25e-12 AS=4.25e-12 PD=6.7e-06 PS=6.7e-06 NRD=0.085 NRS=0.085 $X=335425 $Y=855250 $D=41
M173 VDDA 14 BG_REF VDDA pmos4 L=1e-05 W=5e-06 AD=4.25e-12 AS=4.25e-12 PD=6.7e-06 PS=6.7e-06 NRD=0.085 NRS=0.085 $X=347725 $Y=705650 $D=41
M174 VDDA 14 13 VDDA pmos4 L=1e-05 W=5e-06 AD=4.25e-12 AS=4.25e-12 PD=6.7e-06 PS=6.7e-06 NRD=0.085 NRS=0.085 $X=347725 $Y=724350 $D=41
M175 VDDA 14 BG_REF VDDA pmos4 L=1e-05 W=5e-06 AD=4.25e-12 AS=4.25e-12 PD=6.7e-06 PS=6.7e-06 NRD=0.085 NRS=0.085 $X=347725 $Y=743050 $D=41
M176 VDDA 14 BG_REF VDDA pmos4 L=1e-05 W=5e-06 AD=4.25e-12 AS=4.25e-12 PD=6.7e-06 PS=6.7e-06 NRD=0.085 NRS=0.085 $X=347725 $Y=761750 $D=41
M177 VDDA 14 13 VDDA pmos4 L=1e-05 W=5e-06 AD=4.25e-12 AS=4.25e-12 PD=6.7e-06 PS=6.7e-06 NRD=0.085 NRS=0.085 $X=347725 $Y=780450 $D=41
M178 VDDA 14 BG_REF VDDA pmos4 L=1e-05 W=5e-06 AD=4.25e-12 AS=4.25e-12 PD=6.7e-06 PS=6.7e-06 NRD=0.085 NRS=0.085 $X=347725 $Y=799150 $D=41
M179 VDDA 14 BG_REF VDDA pmos4 L=1e-05 W=5e-06 AD=4.25e-12 AS=4.25e-12 PD=6.7e-06 PS=6.7e-06 NRD=0.085 NRS=0.085 $X=347725 $Y=817850 $D=41
M180 VDDA 14 13 VDDA pmos4 L=1e-05 W=5e-06 AD=4.25e-12 AS=4.25e-12 PD=6.7e-06 PS=6.7e-06 NRD=0.085 NRS=0.085 $X=347725 $Y=836550 $D=41
M181 VDDA 14 BG_REF VDDA pmos4 L=1e-05 W=5e-06 AD=4.25e-12 AS=4.25e-12 PD=6.7e-06 PS=6.7e-06 NRD=0.085 NRS=0.085 $X=347725 $Y=855250 $D=41
M182 VDDA 14 13 VDDA pmos4 L=1e-05 W=5e-06 AD=4.25e-12 AS=4.25e-12 PD=6.7e-06 PS=6.7e-06 NRD=0.085 NRS=0.085 $X=360025 $Y=705650 $D=41
M183 VDDA 14 BG_REF VDDA pmos4 L=1e-05 W=5e-06 AD=4.25e-12 AS=4.25e-12 PD=6.7e-06 PS=6.7e-06 NRD=0.085 NRS=0.085 $X=360025 $Y=724350 $D=41
M184 VDDA 14 BG_REF VDDA pmos4 L=1e-05 W=5e-06 AD=4.25e-12 AS=4.25e-12 PD=6.7e-06 PS=6.7e-06 NRD=0.085 NRS=0.085 $X=360025 $Y=743050 $D=41
M185 VDDA 14 BG_REF VDDA pmos4 L=1e-05 W=5e-06 AD=4.25e-12 AS=4.25e-12 PD=6.7e-06 PS=6.7e-06 NRD=0.085 NRS=0.085 $X=360025 $Y=761750 $D=41
M186 VDDA 14 BG_REF VDDA pmos4 L=1e-05 W=5e-06 AD=4.25e-12 AS=4.25e-12 PD=6.7e-06 PS=6.7e-06 NRD=0.085 NRS=0.085 $X=360025 $Y=780450 $D=41
M187 VDDA 14 BG_REF VDDA pmos4 L=1e-05 W=5e-06 AD=4.25e-12 AS=4.25e-12 PD=6.7e-06 PS=6.7e-06 NRD=0.085 NRS=0.085 $X=360025 $Y=799150 $D=41
M188 VDDA 14 BG_REF VDDA pmos4 L=1e-05 W=5e-06 AD=4.25e-12 AS=4.25e-12 PD=6.7e-06 PS=6.7e-06 NRD=0.085 NRS=0.085 $X=360025 $Y=817850 $D=41
M189 VDDA 14 BG_REF VDDA pmos4 L=1e-05 W=5e-06 AD=4.25e-12 AS=4.25e-12 PD=6.7e-06 PS=6.7e-06 NRD=0.085 NRS=0.085 $X=360025 $Y=836550 $D=41
M190 VDDA 14 13 VDDA pmos4 L=1e-05 W=5e-06 AD=4.25e-12 AS=4.25e-12 PD=6.7e-06 PS=6.7e-06 NRD=0.085 NRS=0.085 $X=360025 $Y=855250 $D=41
M191 VDDA 14 BG_REF VDDA pmos4 L=1e-05 W=5e-06 AD=4.25e-12 AS=4.25e-12 PD=6.7e-06 PS=6.7e-06 NRD=0.085 NRS=0.085 $X=372325 $Y=743050 $D=41
M192 VDDA 14 BG_REF VDDA pmos4 L=1e-05 W=5e-06 AD=4.25e-12 AS=4.25e-12 PD=6.7e-06 PS=6.7e-06 NRD=0.085 NRS=0.085 $X=372325 $Y=761750 $D=41
M193 VDDA 14 13 VDDA pmos4 L=1e-05 W=5e-06 AD=4.25e-12 AS=4.25e-12 PD=6.7e-06 PS=6.7e-06 NRD=0.085 NRS=0.085 $X=372325 $Y=780450 $D=41
M194 VDDA 14 BG_REF VDDA pmos4 L=1e-05 W=5e-06 AD=4.25e-12 AS=4.25e-12 PD=6.7e-06 PS=6.7e-06 NRD=0.085 NRS=0.085 $X=372325 $Y=799150 $D=41
M195 VDDA 14 BG_REF VDDA pmos4 L=1e-05 W=5e-06 AD=4.25e-12 AS=4.25e-12 PD=6.7e-06 PS=6.7e-06 NRD=0.085 NRS=0.085 $X=372325 $Y=817850 $D=41
C196 18 5 $[cpolya] $A=11583 $P=430.5 $X=27750 $Y=583300 $D=58
X351 17 BIAS BIAS GNDA nmos4_CDNS_78073660103127 $T=32050 833850 0 270 $X=31800 $Y=823450
X352 12 16 BIAS GNDA nmos4_CDNS_78073660103127 $T=39400 833850 0 270 $X=39150 $Y=823450
X353 11 14 BIAS GNDA nmos4_CDNS_78073660103127 $T=46800 833850 0 270 $X=46550 $Y=823450
X382 VDDA ICV_43 $T=57075 858950 0 90 $X=44175 $Y=857750
X383 VDDA ICV_43 $T=57075 869950 0 90 $X=44175 $Y=868750
X384 VDDA ICV_43 $T=260175 686950 0 90 $X=247275 $Y=685750
X385 VDDA ICV_43 $T=260175 705650 0 90 $X=247275 $Y=704450
X386 VDDA ICV_43 $T=260175 724350 0 90 $X=247275 $Y=723150
X387 VDDA ICV_43 $T=260175 743050 0 90 $X=247275 $Y=741850
X388 VDDA ICV_43 $T=260175 761750 0 90 $X=247275 $Y=760550
X389 VDDA ICV_43 $T=260175 780450 0 90 $X=247275 $Y=779250
X390 VDDA ICV_43 $T=260175 799150 0 90 $X=247275 $Y=797950
X391 VDDA ICV_43 $T=260175 817850 0 90 $X=247275 $Y=816650
X392 VDDA ICV_43 $T=260175 836550 0 90 $X=247275 $Y=835350
X393 VDDA ICV_43 $T=260175 855250 0 90 $X=247275 $Y=854050
X394 VDDA ICV_43 $T=260175 873950 0 90 $X=247275 $Y=872750
X398 GNDA 12 17 ICV_45 $T=94075 819800 0 90 $X=82125 $Y=819400
X399 GNDA 11 17 ICV_45 $T=94075 829200 0 90 $X=82125 $Y=828800
X400 GNDA 11 17 ICV_45 $T=118675 819800 0 90 $X=106725 $Y=819400
X401 GNDA 12 17 ICV_45 $T=118675 829200 0 90 $X=106725 $Y=828800
X416 GNDA GNDA vert10_4 $T=396200 543600 0 0 $X=396200 $Y=543600
X417 GNDA GNDA vert10_4 $T=396200 561000 0 0 $X=396200 $Y=561000
X418 GNDA GNDA vert10_4 $T=396200 580400 0 0 $X=396200 $Y=580400
X419 GNDA GNDA vert10_4 $T=396200 599800 0 0 $X=396200 $Y=599800
X420 GNDA GNDA vert10_4 $T=396200 621000 0 0 $X=396200 $Y=621000
X421 GNDA GNDA vert10_4 $T=396200 640400 0 0 $X=396200 $Y=640400
X422 GNDA GNDA vert10_4 $T=396200 659800 0 0 $X=396200 $Y=659800
X423 GNDA GNDA GNDA ICV_41 $T=361400 543600 0 0 $X=361400 $Y=543600
X424 15 GNDA 15 ICV_41 $T=361400 561000 0 0 $X=361400 $Y=561000
X425 15 GNDA 15 ICV_41 $T=361400 580400 0 0 $X=361400 $Y=580400
X426 15 GNDA 15 ICV_41 $T=361400 599800 0 0 $X=361400 $Y=599800
X427 15 GNDA 15 ICV_41 $T=361400 621000 0 0 $X=361400 $Y=621000
X428 15 GNDA 15 ICV_41 $T=361400 640400 0 0 $X=361400 $Y=640400
X429 GNDA GNDA GNDA ICV_41 $T=361400 659800 0 0 $X=361400 $Y=659800
X430 GNDA GNDA GNDA ICV_42 $T=291800 543600 0 0 $X=291800 $Y=543600
X431 GNDA 15 15 ICV_42 $T=291800 561000 0 0 $X=291800 $Y=561000
X432 GNDA 15 15 ICV_42 $T=291800 580400 0 0 $X=291800 $Y=580400
X433 GNDA 15 21 ICV_42 $T=291800 599800 0 0 $X=291800 $Y=599800
X434 GNDA 15 15 ICV_42 $T=291800 621000 0 0 $X=291800 $Y=621000
X435 GNDA 15 15 ICV_42 $T=291800 640400 0 0 $X=291800 $Y=640400
X436 GNDA GNDA GNDA ICV_42 $T=291800 659800 0 0 $X=291800 $Y=659800
X437 20 BG_REF rpolyhc_CDNS_78073660103126 $T=440450 548450 0 0 $X=427250 $Y=545100
X438 21 BG_REF rpolyhc_CDNS_78073660103126 $T=610200 548450 0 0 $X=597000 $Y=545100
.ENDS
***************************************
.SUBCKT ICV_37
** N=5 EP=0 IP=8 FDC=0
.ENDS
***************************************
.SUBCKT ICV_38 1 2 3 5
** N=6 EP=4 IP=10 FDC=3
M0 1 1 1 1 nmos4 L=1e-05 W=5e-06 AD=4.25e-12 AS=4.25e-12 PD=6.7e-06 PS=6.7e-06 NRD=0.085 NRS=0.085 $X=0 $Y=850 $D=38
M1 2 5 1 1 nmos4 L=1e-05 W=5e-06 AD=4.25e-12 AS=4.25e-12 PD=6.7e-06 PS=6.7e-06 NRD=0.085 NRS=0.085 $X=0 $Y=13150 $D=37
M2 3 5 1 1 nmos4 L=1e-05 W=5e-06 AD=4.25e-12 AS=4.25e-12 PD=6.7e-06 PS=6.7e-06 NRD=0.085 NRS=0.085 $X=0 $Y=25450 $D=37
.ENDS
***************************************
.SUBCKT ICV_35 3 4 5 7 8 9
** N=9 EP=6 IP=14 FDC=3
M0 4 7 3 9 nmos4 L=1e-05 W=1e-05 AD=8.5e-12 AS=8.5e-12 PD=1.17e-05 PS=1.17e-05 NRD=0.0425 NRS=0.0425 $X=0 $Y=13150 $D=37
M1 5 8 3 9 nmos4 L=1e-05 W=1e-05 AD=8.5e-12 AS=8.5e-12 PD=1.17e-05 PS=1.17e-05 NRD=0.0425 NRS=0.0425 $X=0 $Y=25450 $D=37
M2 5 8 3 9 nmos4 L=1e-05 W=1e-05 AD=8.5e-12 AS=8.5e-12 PD=1.17e-05 PS=1.17e-05 NRD=0.0425 NRS=0.0425 $X=0 $Y=37750 $D=37
.ENDS
***************************************
.SUBCKT ICV_36 1 2 3 4 5 6
** N=6 EP=6 IP=25 FDC=10
M0 3 3 3 3 nmos4 L=1e-05 W=1e-05 AD=8.5e-12 AS=8.5e-12 PD=1.17e-05 PS=1.17e-05 NRD=0.0425 NRS=0.0425 $X=0 $Y=850 $D=38
M1 3 3 3 3 nmos4 L=1e-05 W=1e-05 AD=8.5e-12 AS=8.5e-12 PD=1.17e-05 PS=1.17e-05 NRD=0.0425 NRS=0.0425 $X=0 $Y=111550 $D=38
M2 2 5 1 3 nmos4 L=1e-05 W=1e-05 AD=8.5e-12 AS=8.5e-12 PD=1.17e-05 PS=1.17e-05 NRD=0.0425 NRS=0.0425 $X=0 $Y=50050 $D=37
M3 2 5 1 3 nmos4 L=1e-05 W=1e-05 AD=8.5e-12 AS=8.5e-12 PD=1.17e-05 PS=1.17e-05 NRD=0.0425 NRS=0.0425 $X=0 $Y=99250 $D=37
X5 1 2 4 5 6 3 ICV_35 $T=0 0 0 0 $X=-400 $Y=-250
X6 1 2 4 5 6 3 ICV_35 $T=0 49200 0 0 $X=-400 $Y=48950
.ENDS
***************************************
.SUBCKT PD_C_CDNS_78073660103425
** N=1 EP=0 IP=0 FDC=0
.ENDS
***************************************
.SUBCKT cpolyc_CDNS_78073660103119 2 3
** N=3 EP=2 IP=0 FDC=1
C0 2 3 $[cpolya] $A=5783.44 $P=304.2 $X=1800 $Y=1000 $D=58
.ENDS
***************************************
.SUBCKT pmos4_CDNS_7807366010318
** N=5 EP=0 IP=0 FDC=0
.ENDS
***************************************
.SUBCKT ICV_30 1 2 3 4 5 7
** N=7 EP=6 IP=10 FDC=2
M0 2 5 1 7 pmos4 L=2e-06 W=5e-06 AD=4.25e-12 AS=4.25e-12 PD=6.7e-06 PS=6.7e-06 NRD=0.085 NRS=0.085 $X=0 $Y=850 $D=41
M1 4 5 3 7 pmos4 L=2e-06 W=5e-06 AD=4.25e-12 AS=4.25e-12 PD=6.7e-06 PS=6.7e-06 NRD=0.085 NRS=0.085 $X=0 $Y=5150 $D=41
.ENDS
***************************************
.SUBCKT ICV_31 1 2 3 4 5 6 7 8 9 11
*.CALIBRE ICV_CELL 9
** N=11 EP=10 IP=14 FDC=4
X0 1 3 2 4 9 11 ICV_30 $T=0 0 0 0 $X=-1200 $Y=-1200
X1 5 7 6 8 9 11 ICV_30 $T=0 8600 0 0 $X=-1200 $Y=7400
.ENDS
***************************************
.SUBCKT pmos4_CDNS_78073660103122 1
** N=2 EP=1 IP=0 FDC=1
M0 1 1 1 1 pmos4 L=1e-06 W=1e-05 AD=8.5e-12 AS=8.5e-12 PD=1.17e-05 PS=1.17e-05 NRD=0.0425 NRS=0.0425 $X=0 $Y=850 $D=42
.ENDS
***************************************
.SUBCKT pmos4_CDNS_7807366010319
** N=5 EP=0 IP=0 FDC=0
.ENDS
***************************************
.SUBCKT ICV_32 1 3 5
** N=6 EP=3 IP=10 FDC=1
M0 3 5 1 1 pmos4 L=3e-05 W=1e-05 AD=8.5e-12 AS=8.5e-12 PD=1.17e-05 PS=1.17e-05 NRD=0.0425 NRS=0.0425 $X=0 $Y=33150 $D=41
.ENDS
***************************************
.SUBCKT ICV_33 1 4 5 6 7 8 11
** N=12 EP=7 IP=27 FDC=7
M0 5 11 1 1 pmos4 L=3e-05 W=1e-05 AD=8.5e-12 AS=8.5e-12 PD=1.17e-05 PS=1.17e-05 NRD=0.0425 NRS=0.0425 $X=0 $Y=68750 $D=41
M1 7 11 1 1 pmos4 L=3e-05 W=1e-05 AD=8.5e-12 AS=8.5e-12 PD=1.17e-05 PS=1.17e-05 NRD=0.0425 NRS=0.0425 $X=0 $Y=133350 $D=41
X2 1 pmos4_CDNS_78073660103122 $T=0 0 0 0 $X=-1200 $Y=-1200
X3 1 pmos4_CDNS_78073660103122 $T=0 229400 0 0 $X=-1200 $Y=228200
X5 1 4 11 ICV_32 $T=0 3300 0 0 $X=-1200 $Y=2100
X6 1 6 11 ICV_32 $T=0 67900 0 0 $X=-1200 $Y=66700
X7 1 8 11 ICV_32 $T=0 132500 0 0 $X=-1200 $Y=131300
.ENDS
***************************************
.SUBCKT ND_C_CDNS_78073660103418
** N=2 EP=0 IP=0 FDC=0
.ENDS
***************************************
.SUBCKT ND_C_CDNS_78073660103421
** N=2 EP=0 IP=0 FDC=0
.ENDS
***************************************
.SUBCKT P1_C_CDNS_78073660103402
** N=2 EP=0 IP=0 FDC=0
.ENDS
***************************************
.SUBCKT ND_C_CDNS_78073660103419
** N=2 EP=0 IP=0 FDC=0
.ENDS
***************************************
.SUBCKT Current_Voltage_Reference ibias1 GNDA VDDA VOUT ibias2 VBG_in RESEXT IOUT7 IOUT6 IOUT5 IOUT4 IOUT3 IOUT2 IOUT1 15 16 17 V1000
** N=35 EP=18 IP=303 FDC=142
R0 VOUT 31 L=4.5e-05 W=2e-06 $[rpolyh] $X=156300 $Y=214400 $D=18
R1 V1000 31 L=3e-05 W=2e-06 $[rpolyh] $X=159150 $Y=200550 $D=18
R2 GNDA V1000 L=0.00015011 W=2e-06 $[rpolyh] $X=156350 $Y=182600 $D=17
D3 GNDA VDDA p_nwd AREA=4214.89 PJ=266 $X=34775 $Y=179100 $D=87
D4 GNDA VDDA p_nwd AREA=611.01 PJ=99.6 $X=126100 $Y=202700 $D=87
D5 GNDA 33 p_nwd AREA=471.54 PJ=125.8 $X=151700 $Y=211050 $D=87
D6 GNDA 34 p_nwd AREA=772.072 PJ=125 $X=153350 $Y=175150 $D=87
D7 GNDA 35 p_nwd AREA=341.04 PJ=95.8 $X=154550 $Y=197200 $D=87
D8 GNDA VDDA p_nwd AREA=4216.19 PJ=266.05 $X=215525 $Y=143050 $D=87
D9 GNDA VDDA p_nwd AREA=589.675 PJ=97.3 $X=333350 $Y=45900 $D=87
D10 GNDA VDDA p_nwd AREA=4090.47 PJ=255.9 $X=399625 $Y=36650 $D=87
D11 GNDA VDDA p_nwd AREA=32688.8 PJ=795.6 $X=399625 $Y=115200 $D=87
M12 GNDA GNDA GNDA GNDA nmos4 L=1e-05 W=5e-06 AD=4.25e-12 AS=4.25e-12 PD=6.7e-06 PS=6.7e-06 NRD=0.085 NRS=0.085 $X=87725 $Y=40700 $D=38
M13 GNDA GNDA GNDA GNDA nmos4 L=1e-05 W=5e-06 AD=4.25e-12 AS=4.25e-12 PD=6.7e-06 PS=6.7e-06 NRD=0.085 NRS=0.085 $X=87725 $Y=50500 $D=38
M14 GNDA GNDA GNDA GNDA nmos4 L=1e-05 W=5e-06 AD=4.25e-12 AS=4.25e-12 PD=6.7e-06 PS=6.7e-06 NRD=0.085 NRS=0.085 $X=284575 $Y=43500 $D=38
M15 GNDA GNDA GNDA GNDA nmos4 L=1e-05 W=5e-06 AD=4.25e-12 AS=4.25e-12 PD=6.7e-06 PS=6.7e-06 NRD=0.085 NRS=0.085 $X=284575 $Y=53300 $D=38
M16 ibias2 ibias2 GNDA GNDA nmos4 L=1e-05 W=5e-06 AD=4.25e-12 AS=4.25e-12 PD=6.7e-06 PS=6.7e-06 NRD=0.085 NRS=0.085 $X=272275 $Y=43500 $D=37
M17 24 ibias2 GNDA GNDA nmos4 L=1e-05 W=5e-06 AD=4.25e-12 AS=4.25e-12 PD=6.7e-06 PS=6.7e-06 NRD=0.085 NRS=0.085 $X=272275 $Y=53300 $D=37
M18 VDDA VDDA VDDA VDDA pmos4 L=1e-05 W=1e-05 AD=8.5e-12 AS=8.5e-12 PD=1.17e-05 PS=1.17e-05 NRD=0.0425 NRS=0.0425 $X=88675 $Y=192250 $D=42
M19 VDDA VDDA VDDA VDDA pmos4 L=1e-05 W=1e-05 AD=8.5e-12 AS=8.5e-12 PD=1.17e-05 PS=1.17e-05 NRD=0.0425 NRS=0.0425 $X=88675 $Y=208050 $D=42
M20 VDDA VDDA VDDA VDDA pmos4 L=1e-05 W=1e-05 AD=8.5e-12 AS=8.5e-12 PD=1.17e-05 PS=1.17e-05 NRD=0.0425 NRS=0.0425 $X=269425 $Y=156200 $D=42
M21 VDDA VDDA VDDA VDDA pmos4 L=1e-05 W=1e-05 AD=8.5e-12 AS=8.5e-12 PD=1.17e-05 PS=1.17e-05 NRD=0.0425 NRS=0.0425 $X=269425 $Y=172000 $D=42
M22 VDDA VDDA VDDA VDDA pmos4 L=3e-05 W=1e-05 AD=8.5e-12 AS=8.5e-12 PD=1.17e-05 PS=1.17e-05 NRD=0.0425 NRS=0.0425 $X=428425 $Y=180600 $D=42
M23 VDDA VDDA VDDA VDDA pmos4 L=3e-05 W=1e-05 AD=8.5e-12 AS=8.5e-12 PD=1.17e-05 PS=1.17e-05 NRD=0.0425 NRS=0.0425 $X=622225 $Y=155800 $D=42
M24 VOUT 20 VDDA VDDA pmos4 L=1e-05 W=1e-05 AD=8.5e-12 AS=8.5e-12 PD=1.17e-05 PS=1.17e-05 NRD=0.0425 NRS=0.0425 $X=132050 $Y=210250 $D=41
M25 24 24 32 VDDA pmos4 L=2e-06 W=5e-06 AD=4.25e-12 AS=4.25e-12 PD=6.7e-06 PS=6.7e-06 NRD=0.085 NRS=0.085 $X=342150 $Y=56300 $D=41
M26 29 25 VDDA VDDA pmos4 L=3e-05 W=1e-05 AD=8.5e-12 AS=8.5e-12 PD=1.17e-05 PS=1.17e-05 NRD=0.0425 NRS=0.0425 $X=428425 $Y=137000 $D=41
M27 30 25 VDDA VDDA pmos4 L=3e-05 W=1e-05 AD=8.5e-12 AS=8.5e-12 PD=1.17e-05 PS=1.17e-05 NRD=0.0425 NRS=0.0425 $X=428425 $Y=155800 $D=41
M28 26 25 VDDA VDDA pmos4 L=3e-05 W=1e-05 AD=8.5e-12 AS=8.5e-12 PD=1.17e-05 PS=1.17e-05 NRD=0.0425 NRS=0.0425 $X=428425 $Y=199400 $D=41
M29 IOUT7 24 17 VDDA pmos4 L=2e-06 W=5e-06 AD=4.25e-12 AS=4.25e-12 PD=6.7e-06 PS=6.7e-06 NRD=0.085 NRS=0.085 $X=457175 $Y=66950 $D=41
M30 26 25 VDDA VDDA pmos4 L=3e-05 W=1e-05 AD=8.5e-12 AS=8.5e-12 PD=1.17e-05 PS=1.17e-05 NRD=0.0425 NRS=0.0425 $X=622225 $Y=137000 $D=41
M31 30 25 VDDA VDDA pmos4 L=3e-05 W=1e-05 AD=8.5e-12 AS=8.5e-12 PD=1.17e-05 PS=1.17e-05 NRD=0.0425 NRS=0.0425 $X=622225 $Y=180600 $D=41
M32 29 25 VDDA VDDA pmos4 L=3e-05 W=1e-05 AD=8.5e-12 AS=8.5e-12 PD=1.17e-05 PS=1.17e-05 NRD=0.0425 NRS=0.0425 $X=622225 $Y=199400 $D=41
C33 GNDA ibias1 $[cpolya] $A=1196 $P=139.8 $X=61100 $Y=75350 $D=58
C34 GNDA VDDA $[cpolya] $A=9007.5 $P=420.1 $X=519150 $Y=24450 $D=58
X39 VDDA 21 20 21 ICV_40 $T=50925 202250 0 270 $X=49725 $Y=191050
X40 VDDA 20 21 21 ICV_40 $T=50925 218050 0 270 $X=49725 $Y=206850
X41 VDDA 23 25 23 ICV_40 $T=231675 166200 0 270 $X=230475 $Y=155000
X42 VDDA 25 23 23 ICV_40 $T=231675 182000 0 270 $X=230475 $Y=170800
X43 VDDA 32 32 VDDA pmos4_CDNS_7807366010317 $T=345600 61300 0 270 $X=344400 $Y=55100
X46 GNDA 19 ibias1 ibias1 ICV_38 $T=49975 45700 0 270 $X=49725 $Y=40300
X47 GNDA ibias1 19 ibias1 ICV_38 $T=49975 55500 0 270 $X=49725 $Y=50100
X48 GNDA 24 22 ibias2 ICV_38 $T=234525 48500 0 270 $X=234275 $Y=43100
X49 GNDA ibias2 22 ibias2 ICV_38 $T=234525 58300 0 270 $X=234275 $Y=52900
X50 19 21 GNDA 20 31 VBG_in ICV_36 $T=53775 138750 0 270 $X=53525 $Y=128350
X51 19 20 GNDA 21 VBG_in 31 ICV_36 $T=53775 155550 0 270 $X=53525 $Y=145150
X52 22 23 GNDA 25 RESEXT VBG_in ICV_36 $T=234525 102700 0 270 $X=234275 $Y=92300
X53 22 25 GNDA 23 VBG_in RESEXT ICV_36 $T=234525 119500 0 270 $X=234275 $Y=109100
X62 VOUT 20 cpolyc_CDNS_78073660103119 $T=209900 29650 1 180 $X=129300 $Y=28300
X63 RESEXT 25 cpolyc_CDNS_78073660103119 $T=380600 148300 1 180 $X=300000 $Y=146950
X66 30 30 RESEXT RESEXT 30 30 RESEXT RESEXT 24 VDDA ICV_31 $T=404725 71950 0 270 $X=403525 $Y=65750
X67 30 30 RESEXT RESEXT 26 27 IOUT1 IOUT2 24 VDDA ICV_31 $T=421925 71950 0 270 $X=420725 $Y=65750
X68 28 29 IOUT3 IOUT4 15 16 IOUT5 IOUT6 24 VDDA ICV_31 $T=439125 71950 0 270 $X=437925 $Y=65750
X69 VDDA 30 28 30 27 30 25 ICV_33 $T=424275 147000 0 270 $X=423075 $Y=135800
X70 VDDA 17 30 16 30 15 25 ICV_33 $T=424275 165800 0 270 $X=423075 $Y=154600
X71 VDDA 15 30 16 30 17 25 ICV_33 $T=424275 190600 0 270 $X=423075 $Y=179400
X72 VDDA 30 27 30 28 30 25 ICV_33 $T=424275 209400 0 270 $X=423075 $Y=198200
.ENDS
***************************************
.SUBCKT ECG_BIAS VDDA 2 3 GNDA VOUT IOUT7 IOUT6 IOUT5 IOUT4 IOUT1 IOUT3 RESEXT IOUT2 V1000
** N=19 EP=14 IP=72 FDC=491
X0 VDDA GNDA V500_20 $T=1172850 -454600 0 0 $X=1172650 $Y=-454650
X1 VDDA GNDA V500_20 $T=1172900 -857250 1 0 $X=1172700 $Y=-881350
X2 VDDA GNDA V500_20 $T=1742900 -857250 1 0 $X=1742700 $Y=-881350
X3 VDDA GNDA V500_20 $T=1776100 -454600 0 0 $X=1775900 $Y=-454650
X4 VDDA GNDA V500_20 $T=2276800 -857250 1 0 $X=2276600 $Y=-881350
X5 VDDA GNDA V500_20 $T=2289600 -783300 0 0 $X=2289400 $Y=-783350
X6 VDDA GNDA V500_20 $T=2289600 -746350 0 0 $X=2289400 $Y=-746400
X7 VDDA GNDA V500_20 $T=2289650 -822550 0 0 $X=2289450 $Y=-822600
X8 VDDA GNDA V500_20 $T=2407200 -454600 0 0 $X=2407000 $Y=-454650
X9 VDDA GNDA V200_20 $T=1137675 -497925 1 270 $X=1113625 $Y=-697975
X10 VDDA GNDA V200_20 $T=1239450 -667350 0 0 $X=1239500 $Y=-667400
X11 VDDA GNDA V200_20 $T=1239500 -747850 0 0 $X=1239550 $Y=-747900
X12 VDDA GNDA V200_20 $T=1239500 -706000 0 0 $X=1239550 $Y=-706050
X13 VDDA GNDA V200_20 $T=1239550 -829900 0 0 $X=1239600 $Y=-829950
X14 VDDA GNDA V200_20 $T=1239550 -790200 0 0 $X=1239600 $Y=-790250
X15 VDDA GNDA V200_20 $T=1446775 -512425 0 270 $X=1446725 $Y=-712475
X16 VDDA GNDA V200_20 $T=2236525 -524375 0 270 $X=2236475 $Y=-724425
X17 VDDA GNDA V200_20 $T=2958075 -524375 0 270 $X=2958025 $Y=-724425
X18 VDDA GNDA 15 3 2 Constant_gm $T=1028550 -457100 0 0 $X=1145975 $Y=-626252
X19 GNDA VDDA 16 15 ECG_bandgap_f_v1 $T=1463450 -1371700 0 0 $X=1477550 $Y=-837402
X20 3 GNDA VDDA VOUT 2 16 RESEXT IOUT7 IOUT6 IOUT5 IOUT4 IOUT3 IOUT2 IOUT1 19 18 17 V1000 Current_Voltage_Reference $T=2240150 -717200 0 0 $X=2269925 $Y=-701652
.ENDS
***************************************
.SUBCKT g_padonly
** N=1 EP=0 IP=0 FDC=0
.ENDS
***************************************
.SUBCKT APRIO200P vdd3r! gnd3r! gnd3o! vdd3o! PAD Z
** N=8 EP=6 IP=1 FDC=29
R0 8 PAD L=2.1e-05 W=5.5e-06 $[rpoly2] $X=15100 $Y=221900 $D=14
R1 Z 8 L=2.1e-05 W=5.5e-06 $[rpoly2] $X=15100 $Y=227900 $D=14
R2 PAD PAD L=1.05e-05 W=5.5e-06 $[rpoly2] $X=25600 $Y=215900 $D=14
R3 Z Z L=2.1e-05 W=5.5e-06 $[rpoly2] $X=39500 $Y=215900 $D=14
R4 PAD 8 L=2.1e-05 W=5.5e-06 $[rpoly2] $X=39500 $Y=221900 $D=14
R5 8 Z L=2.1e-05 W=5.5e-06 $[rpoly2] $X=39500 $Y=227900 $D=14
R6 Z Z L=2.1e-05 W=5.5e-06 $[rpoly2] $X=63900 $Y=215900 $D=14
R7 Z Z L=2.1e-05 W=5.5e-06 $[rpoly2] $X=63900 $Y=221900 $D=14
R8 Z Z L=2.1e-05 W=5.5e-06 $[rpoly2] $X=63900 $Y=227900 $D=14
D9 gnd3o! PAD nd AREA=50.89 PJ=146.8 $X=13400 $Y=106800 $D=63
D10 gnd3o! PAD nd AREA=50.89 PJ=146.8 $X=13400 $Y=109400 $D=63
D11 gnd3o! PAD nd AREA=50.89 PJ=146.8 $X=13400 $Y=112000 $D=63
D12 gnd3o! PAD nd AREA=50.89 PJ=146.8 $X=13400 $Y=114600 $D=63
D13 gnd3o! PAD nd AREA=50.89 PJ=146.8 $X=13400 $Y=117200 $D=63
D14 gnd3o! PAD nd AREA=50.89 PJ=146.8 $X=13400 $Y=119800 $D=63
D15 gnd3o! PAD nd AREA=50.89 PJ=146.8 $X=13400 $Y=122400 $D=63
D16 gnd3r! Z nd AREA=6.5 PJ=9.42843 $X=48750 $Y=284700 $D=63
D17 PAD vdd3o! pd AREA=50.89 PJ=146.8 $X=13400 $Y=180900 $D=64
D18 PAD vdd3o! pd AREA=50.89 PJ=146.8 $X=13400 $Y=183500 $D=64
D19 PAD vdd3o! pd AREA=50.89 PJ=146.8 $X=13400 $Y=186100 $D=64
D20 PAD vdd3o! pd AREA=50.89 PJ=146.8 $X=13400 $Y=188700 $D=64
D21 PAD vdd3o! pd AREA=50.89 PJ=146.8 $X=13400 $Y=191300 $D=64
D22 PAD vdd3o! pd AREA=50.89 PJ=146.8 $X=13400 $Y=193900 $D=64
D23 PAD vdd3o! pd AREA=50.89 PJ=146.8 $X=13400 $Y=196500 $D=64
D24 Z vdd3r! pd AREA=6.5 PJ=9.42843 $X=48750 $Y=259050 $D=64
D25 gnd3o! vdd3o! nwd AREA=866.32 PJ=502.8 $X=1500 $Y=99800 $D=65
D26 gnd3r! vdd3r! nwd AREA=450.8 PJ=412.5 $X=1500 $Y=313700 $D=65
D27 gnd3o! vdd3o! nwd AREA=1461.01 PJ=190 $X=11900 $Y=179400 $D=65
D28 gnd3r! vdd3r! nwd AREA=10.54 PJ=1.054e-49 $X=48450 $Y=258250 $D=65
.ENDS
***************************************
.SUBCKT AGND3ALLP vdd3r! gnd3r! gnd3o! vdd3o! A
** N=7 EP=5 IP=1 FDC=23
R0 gnd3o! 7 L=0.000437568 W=4e-07 $[rpoly1] $X=17950 $Y=144400 $D=8
D1 gnd3r! vdd3r! nwd AREA=2395.9 PJ=195.1 $X=1500 $Y=256750 $D=65
D2 gnd3r! vdd3r! nwd AREA=1910.9 PJ=195.1 $X=1500 $Y=313700 $D=65
D3 gnd3o! vdd3o! nwd AREA=1357.28 PJ=798.4 $X=24950 $Y=107550 $D=65
D4 gnd3o! vdd3o! nwd AREA=516.32 PJ=242.057 $X=39500 $Y=119350 $D=65
D5 gnd3o! vdd3o! nwd AREA=516.32 PJ=242.057 $X=56200 $Y=119350 $D=65
D6 gnd3o! vdd3o! nwd AREA=516.32 PJ=242.057 $X=72900 $Y=119350 $D=65
X7 A gnd3o! rx number_of_via1=276 $[short_via] $X=22050 $Y=111300 $D=5
X8 A gnd3o! rx number_of_via1=520 $[short_via] $X=29350 $Y=112700 $D=5
X9 A gnd3o! rx number_of_via1=394 $[short_via] $X=46300 $Y=112250 $D=5
X10 A gnd3o! rx number_of_via1=394 $[short_via] $X=64800 $Y=112250 $D=5
X11 A gnd3o! rx number_of_via1=514 $[short_via] $X=81500 $Y=117075 $D=5
X12 A gnd3o! rx number_of_via1=310 $[short_via] $X=96100 $Y=104700 $D=5
X13 gnd3r! A rx number_of_via2=598 $[short_via] $X=12100 $Y=284650 $D=6
X14 gnd3r! A rx number_of_via2=572 $[short_via] $X=38450 $Y=284650 $D=6
X15 gnd3o! A rx number_of_via2=3790 $[short_via] $X=12850 $Y=105450 $D=6
X16 gnd3r! A rx number_of_via2=598 $[short_via] $X=64550 $Y=284650 $D=6
M17 vdd3o! 7 gnd3o! gnd3o! nmos4 L=5.5e-07 W=0.0001218 AD=6.30315e-10 AS=2.16195e-10 PD=1.035e-05 PS=0.00012535 NRD=0.00348933 NRS=0.00348933 $X=35975 $Y=116350 $D=37
M18 gnd3o! 7 vdd3o! gnd3o! nmos4 L=5.5e-07 W=0.0001218 AD=2.04015e-10 AS=6.30315e-10 PD=0.00012515 PS=1.035e-05 NRD=0.00348933 NRS=0.00348933 $X=46875 $Y=116350 $D=37
M19 vdd3o! 7 gnd3o! gnd3o! nmos4 L=5.5e-07 W=0.0001218 AD=6.30315e-10 AS=2.04015e-10 PD=1.035e-05 PS=0.00012515 NRD=0.00348933 NRS=0.00348933 $X=52675 $Y=116350 $D=37
M20 gnd3o! 7 vdd3o! gnd3o! nmos4 L=5.5e-07 W=0.0001218 AD=2.04015e-10 AS=6.30315e-10 PD=0.00012515 PS=1.035e-05 NRD=0.00348933 NRS=0.00348933 $X=63575 $Y=116350 $D=37
M21 vdd3o! 7 gnd3o! gnd3o! nmos4 L=5.5e-07 W=0.0001218 AD=6.30315e-10 AS=2.04015e-10 PD=1.035e-05 PS=0.00012515 NRD=0.00348933 NRS=0.00348933 $X=69375 $Y=116350 $D=37
M22 gnd3o! 7 vdd3o! gnd3o! nmos4 L=5.5e-07 W=0.0001218 AD=2.16195e-10 AS=6.30315e-10 PD=0.00012535 PS=1.035e-05 NRD=0.00348933 NRS=0.00348933 $X=80275 $Y=116350 $D=37
.ENDS
***************************************
.SUBCKT AVDD3ALLP vdd3r! gnd3r! gnd3o! vdd3o! A
** N=7 EP=5 IP=1 FDC=19
R0 gnd3o! 7 L=0.000437491 W=4e-07 $[rpoly1] $X=5650 $Y=261600 $D=8
D1 gnd3r! vdd3r! nwd AREA=2395.9 PJ=195.1 $X=1500 $Y=256750 $D=65
D2 gnd3r! vdd3r! nwd AREA=1910.9 PJ=195.1 $X=1500 $Y=313700 $D=65
D3 gnd3o! A nwd AREA=1552.44 PJ=801.2 $X=24950 $Y=107550 $D=65
D4 gnd3o! A nwd AREA=516.32 PJ=242.057 $X=39500 $Y=119350 $D=65
D5 gnd3o! A nwd AREA=516.32 PJ=242.057 $X=56200 $Y=119350 $D=65
D6 gnd3o! A nwd AREA=516.32 PJ=242.057 $X=72900 $Y=119350 $D=65
X7 vdd3r! A rx number_of_via2=462 $[short_via] $X=12900 $Y=258400 $D=6
X8 vdd3r! A rx number_of_via2=462 $[short_via] $X=38500 $Y=258400 $D=6
X9 vdd3o! A rx number_of_via2=3891 $[short_via] $X=12900 $Y=179800 $D=6
X10 vdd3r! A rx number_of_via2=1020 $[short_via] $X=12100 $Y=316250 $D=6
X11 vdd3o! A rx number_of_via2=124 $[short_via] $X=86100 $Y=179800 $D=6
X12 vdd3r! A rx number_of_via2=378 $[short_via] $X=64600 $Y=258400 $D=6
M13 A 7 gnd3o! gnd3o! nmos4 L=5.5e-07 W=0.0001218 AD=6.30315e-10 AS=2.16195e-10 PD=1.035e-05 PS=0.00012535 NRD=0.00348933 NRS=0.00348933 $X=35975 $Y=116350 $D=37
M14 gnd3o! 7 A gnd3o! nmos4 L=5.5e-07 W=0.0001218 AD=2.04015e-10 AS=6.30315e-10 PD=0.00012515 PS=1.035e-05 NRD=0.00348933 NRS=0.00348933 $X=46875 $Y=116350 $D=37
M15 A 7 gnd3o! gnd3o! nmos4 L=5.5e-07 W=0.0001218 AD=6.30315e-10 AS=2.04015e-10 PD=1.035e-05 PS=0.00012515 NRD=0.00348933 NRS=0.00348933 $X=52675 $Y=116350 $D=37
M16 gnd3o! 7 A gnd3o! nmos4 L=5.5e-07 W=0.0001218 AD=2.04015e-10 AS=6.30315e-10 PD=0.00012515 PS=1.035e-05 NRD=0.00348933 NRS=0.00348933 $X=63575 $Y=116350 $D=37
M17 A 7 gnd3o! gnd3o! nmos4 L=5.5e-07 W=0.0001218 AD=6.30315e-10 AS=2.04015e-10 PD=1.035e-05 PS=0.00012515 NRD=0.00348933 NRS=0.00348933 $X=69375 $Y=116350 $D=37
M18 gnd3o! 7 A gnd3o! nmos4 L=5.5e-07 W=0.0001218 AD=2.16195e-10 AS=6.30315e-10 PD=0.00012535 PS=1.035e-05 NRD=0.00348933 NRS=0.00348933 $X=80275 $Y=116350 $D=37
.ENDS
***************************************
.SUBCKT ICV_2
** N=7 EP=0 IP=10 FDC=0
.ENDS
***************************************
.SUBCKT ICV_4 2 3 4 5 6
** N=7 EP=5 IP=14 FDC=3
M0 2 6 3 3 pmos4 L=1e-05 W=5e-06 AD=4.25e-12 AS=4.25e-12 PD=6.7e-06 PS=6.7e-06 NRD=0.085 NRS=0.085 $X=6250 $Y=850 $D=41
M1 4 6 3 3 pmos4 L=1e-05 W=5e-06 AD=4.25e-12 AS=4.25e-12 PD=6.7e-06 PS=6.7e-06 NRD=0.085 NRS=0.085 $X=12500 $Y=850 $D=41
M2 5 6 3 3 pmos4 L=1e-05 W=5e-06 AD=4.25e-12 AS=4.25e-12 PD=6.7e-06 PS=6.7e-06 NRD=0.085 NRS=0.085 $X=18750 $Y=850 $D=41
.ENDS
***************************************
.SUBCKT ICV_5
** N=7 EP=0 IP=10 FDC=0
.ENDS
***************************************
.SUBCKT ICV_1 3 4 5
** N=5 EP=3 IP=8 FDC=1
M0 4 5 3 3 nmos4 L=1e-05 W=5e-06 AD=4.25e-12 AS=4.25e-12 PD=6.7e-06 PS=6.7e-06 NRD=0.085 NRS=0.085 $X=6250 $Y=850 $D=37
.ENDS
***************************************
.SUBCKT ICV_3 3 4 5 6
** N=6 EP=4 IP=10 FDC=3
M0 5 6 3 3 nmos4 L=1e-05 W=5e-06 AD=4.25e-12 AS=4.25e-12 PD=6.7e-06 PS=6.7e-06 NRD=0.085 NRS=0.085 $X=12500 $Y=850 $D=37
X1 3 4 6 ICV_1 $T=0 0 0 0 $X=-400 $Y=-250
X2 3 6 6 ICV_1 $T=12500 0 0 0 $X=12100 $Y=-250
.ENDS
***************************************
.SUBCKT cvar_CDNS_7807366010313 1 2
** N=2 EP=2 IP=0 FDC=2
M0 2 1 2 1 cvar w=0.000792 l=6.5e-07 cols=12 rows=10 $X=0 $Y=0 $D=62
D1 1 2 p_nwd AREA=1709.1 PJ=204.2 $X=-300 $Y=-300 $D=87
.ENDS
***************************************
.SUBCKT fbias_por2_fc GNDA BIAS VDDA VBG POR_L
** N=13 EP=5 IP=124 FDC=67
R0 GNDA 12 L=0.00099985 W=8e-07 $[rpolyh] $X=84750 $Y=50650 $D=18
R1 12 VDDA L=0.00139975 W=8e-07 $[rpolyh] $X=84750 $Y=112600 $D=18
D2 GNDA VDDA p_nwd AREA=1899.48 PJ=196.7 $X=1700 $Y=116750 $D=87
D3 GNDA VDDA p_nwd AREA=638.715 PJ=101.3 $X=7325 $Y=88800 $D=87
D4 GNDA VDDA p_nwd AREA=1457.68 PJ=161.2 $X=9800 $Y=145900 $D=87
D5 GNDA GNDA p_nwd AREA=6421.88 PJ=390.6 $X=77600 $Y=42500 $D=87
D6 GNDA VDDA p_nwd AREA=45.625 PJ=27.1 $X=109550 $Y=17550 $D=87
M7 BIAS BIAS BIAS GNDA nmos4 L=1e-05 W=5e-06 AD=4.25e-12 AS=4.25e-12 PD=6.7e-06 PS=6.7e-06 NRD=0.085 NRS=0.085 $X=18475 $Y=14650 $D=38
M8 BIAS BIAS BIAS GNDA nmos4 L=1e-05 W=5e-06 AD=4.25e-12 AS=4.25e-12 PD=6.7e-06 PS=6.7e-06 NRD=0.085 NRS=0.085 $X=80975 $Y=14650 $D=38
M9 10 10 GNDA GNDA nmos4 L=1e-05 W=1e-05 AD=8.5e-12 AS=8.5e-12 PD=1.17e-05 PS=1.17e-05 NRD=0.0425 NRS=0.0425 $X=19725 $Y=51100 $D=37
M10 6 10 GNDA GNDA nmos4 L=1e-05 W=1e-05 AD=8.5e-12 AS=8.5e-12 PD=1.17e-05 PS=1.17e-05 NRD=0.0425 NRS=0.0425 $X=19725 $Y=65600 $D=37
M11 6 10 GNDA GNDA nmos4 L=1e-05 W=1e-05 AD=8.5e-12 AS=8.5e-12 PD=1.17e-05 PS=1.17e-05 NRD=0.0425 NRS=0.0425 $X=32025 $Y=51100 $D=37
M12 10 10 GNDA GNDA nmos4 L=1e-05 W=1e-05 AD=8.5e-12 AS=8.5e-12 PD=1.17e-05 PS=1.17e-05 NRD=0.0425 NRS=0.0425 $X=32025 $Y=65600 $D=37
M13 7 BIAS GNDA GNDA nmos4 L=1e-05 W=5e-06 AD=4.25e-12 AS=4.25e-12 PD=6.7e-06 PS=6.7e-06 NRD=0.085 NRS=0.085 $X=43475 $Y=14650 $D=37
M14 7 BIAS GNDA GNDA nmos4 L=1e-05 W=5e-06 AD=4.25e-12 AS=4.25e-12 PD=6.7e-06 PS=6.7e-06 NRD=0.085 NRS=0.085 $X=68475 $Y=14650 $D=37
M15 9 6 GNDA GNDA nmos4 L=1e-06 W=2.5e-06 AD=1.25e-12 AS=2.125e-12 PD=1e-06 PS=4.2e-06 NRD=0.17 NRS=0.17 $X=95150 $Y=20800 $D=37
M16 GNDA 6 9 GNDA nmos4 L=1e-06 W=2.5e-06 AD=1.25e-12 AS=1.25e-12 PD=1e-06 PS=1e-06 NRD=0.17 NRS=0.17 $X=97150 $Y=20800 $D=37
M17 9 6 GNDA GNDA nmos4 L=1e-06 W=2.5e-06 AD=1.25e-12 AS=1.25e-12 PD=1e-06 PS=1e-06 NRD=0.17 NRS=0.17 $X=99150 $Y=20800 $D=37
M18 GNDA 6 9 GNDA nmos4 L=1e-06 W=2.5e-06 AD=2.125e-12 AS=1.25e-12 PD=4.2e-06 PS=1e-06 NRD=0.17 NRS=0.17 $X=101150 $Y=20800 $D=37
M19 POR_L 13 GNDA GNDA nmos4 L=3.5e-07 W=8e-07 AD=6.8e-13 AS=1.11e-12 PD=2.5e-06 PS=5.3e-06 NRD=0.53125 NRS=0.53125 $X=114350 $Y=15550 $D=37
M20 7 7 7 VDDA pmos4 L=1e-05 W=5e-06 AD=4.25e-12 AS=4.25e-12 PD=6.7e-06 PS=6.7e-06 NRD=0.085 NRS=0.085 $X=7050 $Y=125950 $D=42
M21 11 11 11 VDDA pmos4 L=5e-07 W=5e-06 AD=4.25e-12 AS=4.25e-12 PD=6.7e-06 PS=6.7e-06 NRD=0.085 NRS=0.085 $X=13550 $Y=100150 $D=42
M22 8 8 8 VDDA pmos4 L=1e-05 W=5e-06 AD=4.25e-12 AS=4.25e-12 PD=6.7e-06 PS=6.7e-06 NRD=0.085 NRS=0.085 $X=15150 $Y=153100 $D=42
M23 11 11 11 VDDA pmos4 L=5e-07 W=5e-06 AD=4.25e-12 AS=4.25e-12 PD=6.7e-06 PS=6.7e-06 NRD=0.085 NRS=0.085 $X=27550 $Y=100150 $D=42
M24 8 8 8 VDDA pmos4 L=1e-05 W=5e-06 AD=4.25e-12 AS=4.25e-12 PD=6.7e-06 PS=6.7e-06 NRD=0.085 NRS=0.085 $X=52650 $Y=153100 $D=42
M25 7 7 7 VDDA pmos4 L=1e-05 W=5e-06 AD=4.25e-12 AS=4.25e-12 PD=6.7e-06 PS=6.7e-06 NRD=0.085 NRS=0.085 $X=63300 $Y=125950 $D=42
M26 10 VBG 11 VDDA pmos4 L=5e-07 W=5e-06 AD=4.25e-12 AS=4.25e-12 PD=6.7e-06 PS=6.7e-06 NRD=0.085 NRS=0.085 $X=16350 $Y=100150 $D=41
M27 6 12 11 VDDA pmos4 L=5e-07 W=5e-06 AD=4.25e-12 AS=4.25e-12 PD=6.7e-06 PS=6.7e-06 NRD=0.085 NRS=0.085 $X=19150 $Y=100150 $D=41
M28 10 VBG 11 VDDA pmos4 L=5e-07 W=5e-06 AD=4.25e-12 AS=4.25e-12 PD=6.7e-06 PS=6.7e-06 NRD=0.085 NRS=0.085 $X=21950 $Y=100150 $D=41
M29 6 12 11 VDDA pmos4 L=5e-07 W=5e-06 AD=4.25e-12 AS=4.25e-12 PD=6.7e-06 PS=6.7e-06 NRD=0.085 NRS=0.085 $X=24750 $Y=100150 $D=41
M30 VDDA 7 11 VDDA pmos4 L=1e-05 W=5e-06 AD=4.25e-12 AS=4.25e-12 PD=6.7e-06 PS=6.7e-06 NRD=0.085 NRS=0.085 $X=32050 $Y=125950 $D=41
M31 8 8 VDDA VDDA pmos4 L=1e-05 W=5e-06 AD=4.25e-12 AS=4.25e-12 PD=6.7e-06 PS=6.7e-06 NRD=0.085 NRS=0.085 $X=40150 $Y=153100 $D=41
M32 8 8 VDDA VDDA pmos4 L=1e-05 W=5e-06 AD=4.25e-12 AS=4.25e-12 PD=6.7e-06 PS=6.7e-06 NRD=0.085 NRS=0.085 $X=46400 $Y=153100 $D=41
M33 VDDA 7 7 VDDA pmos4 L=1e-05 W=5e-06 AD=4.25e-12 AS=4.25e-12 PD=6.7e-06 PS=6.7e-06 NRD=0.085 NRS=0.085 $X=57050 $Y=125950 $D=41
M34 POR_L 13 VDDA VDDA pmos4 L=3.5e-07 W=1.4e-06 AD=9.45e-13 AS=1.47e-12 PD=3.1e-06 PS=3.8e-06 NRD=0.303571 NRS=0.303571 $X=114450 $Y=18750 $D=41
C35 GNDA VDDA $[cpolya] $A=975 $P=160 $X=5450 $Y=177700 $D=58
C36 GNDA BIAS $[cpolya] $A=840 $P=148 $X=58900 $Y=45750 $D=58
X40 9 VDDA GNDA 13 INVX1 $T=110400 12350 0 0 $X=109550 $Y=11000
X51 7 VDDA 11 7 7 ICV_4 $T=7050 136800 1 0 $X=5850 $Y=123900
X52 8 VDDA 8 9 8 ICV_4 $T=15150 152250 0 0 $X=13950 $Y=151050
X53 11 VDDA 7 11 7 ICV_4 $T=32050 136800 1 0 $X=30850 $Y=123900
X57 GNDA BIAS BIAS ICV_1 $T=68475 13800 0 0 $X=68075 $Y=13550
X58 GNDA BIAS 7 BIAS ICV_3 $T=18475 13800 0 0 $X=18075 $Y=13550
X59 GNDA 8 7 BIAS ICV_3 $T=43475 13800 0 0 $X=43075 $Y=13550
X60 GNDA 9 cvar_CDNS_7807366010313 $T=125750 26550 0 0 $X=123475 $Y=25000
X61 GNDA 9 cvar_CDNS_7807366010313 $T=125750 114300 0 0 $X=123475 $Y=112750
X62 GNDA 9 cvar_CDNS_7807366010313 $T=152200 26550 0 0 $X=149925 $Y=25000
X63 GNDA 9 cvar_CDNS_7807366010313 $T=152200 114300 0 0 $X=149925 $Y=112750
X64 GNDA 9 cvar_CDNS_7807366010313 $T=178650 26550 0 0 $X=176375 $Y=25000
X65 GNDA 9 cvar_CDNS_7807366010313 $T=178650 114300 0 0 $X=176375 $Y=112750
.ENDS
***************************************
.SUBCKT P1_C_CDNS_78073660103215
** N=2 EP=0 IP=0 FDC=0
.ENDS
***************************************
.SUBCKT pmos4_CDNS_7807366010330 1 2 3 5
** N=5 EP=4 IP=0 FDC=1
M0 2 3 1 5 pmos4 L=2e-05 W=2e-05 AD=1.7e-11 AS=1.7e-11 PD=2.17e-05 PS=2.17e-05 NRD=0.02125 NRS=0.02125 $X=0 $Y=850 $D=41
.ENDS
***************************************
.SUBCKT pmos4_CDNS_7807366010333
** N=5 EP=0 IP=0 FDC=0
.ENDS
***************************************
.SUBCKT ICV_6
** N=7 EP=0 IP=10 FDC=0
.ENDS
***************************************
.SUBCKT ICV_7 3 4 5 8
** N=9 EP=4 IP=14 FDC=2
M0 4 8 3 3 pmos4 L=2e-05 W=4e-06 AD=3.4e-12 AS=3.4e-12 PD=5.7e-06 PS=5.7e-06 NRD=0.10625 NRS=0.10625 $X=5250 $Y=850 $D=41
M1 5 8 3 3 pmos4 L=2e-05 W=4e-06 AD=3.4e-12 AS=3.4e-12 PD=5.7e-06 PS=5.7e-06 NRD=0.10625 NRS=0.10625 $X=10500 $Y=850 $D=41
.ENDS
***************************************
.SUBCKT P1_C_CDNS_78073660103217
** N=2 EP=0 IP=0 FDC=0
.ENDS
***************************************
.SUBCKT nmos4_CDNS_7807366010334
** N=4 EP=0 IP=0 FDC=0
.ENDS
***************************************
.SUBCKT ICV_8
** N=6 EP=0 IP=8 FDC=0
.ENDS
***************************************
.SUBCKT fbias_gm_c1_f2c OUT1 OUT4 OUT3 OUT2 GNDA VDDA
** N=18 EP=6 IP=155 FDC=59
R0 GNDA 17 L=0.00037505 W=2e-06 $[rpolyh] $X=118450 $Y=23450 $D=18
D1 GNDA VDDA p_nwd AREA=5133.78 PJ=381.7 $X=7050 $Y=167500 $D=87
D2 GNDA VDDA p_nwd AREA=3918.78 PJ=306.7 $X=7250 $Y=105000 $D=87
D3 GNDA GNDA p_nwd AREA=2175.26 PJ=188.2 $X=111400 $Y=16400 $D=87
D4 GNDA VDDA p_nwd AREA=96.32 PJ=39.6 $X=131600 $Y=76000 $D=87
M5 16 16 16 GNDA nmos4 L=2e-05 W=5e-06 AD=4.25e-12 AS=4.25e-12 PD=6.7e-06 PS=6.7e-06 NRD=0.085 NRS=0.085 $X=28650 $Y=26800 $D=38
M6 16 16 16 GNDA nmos4 L=2e-05 W=5e-06 AD=4.25e-12 AS=4.25e-12 PD=6.7e-06 PS=6.7e-06 NRD=0.085 NRS=0.085 $X=97400 $Y=26800 $D=38
M7 13 8 15 GNDA nmos4 L=2e-05 W=1e-05 AD=5e-12 AS=8.5e-12 PD=1e-06 PS=1.17e-05 NRD=0.0425 NRS=0.0425 $X=14875 $Y=68450 $D=37
M8 15 16 17 GNDA nmos4 L=2e-05 W=5e-06 AD=4.25e-12 AS=4.25e-12 PD=6.7e-06 PS=6.7e-06 NRD=0.085 NRS=0.085 $X=34900 $Y=26800 $D=37
M9 15 8 13 GNDA nmos4 L=2e-05 W=1e-05 AD=5e-12 AS=5e-12 PD=1e-06 PS=1e-06 NRD=0.0425 NRS=0.0425 $X=35875 $Y=68450 $D=37
M10 15 16 17 GNDA nmos4 L=2e-05 W=5e-06 AD=4.25e-12 AS=4.25e-12 PD=6.7e-06 PS=6.7e-06 NRD=0.085 NRS=0.085 $X=41150 $Y=26800 $D=37
M11 15 16 17 GNDA nmos4 L=2e-05 W=5e-06 AD=4.25e-12 AS=4.25e-12 PD=6.7e-06 PS=6.7e-06 NRD=0.085 NRS=0.085 $X=47400 $Y=26800 $D=37
M12 16 16 GNDA GNDA nmos4 L=2e-05 W=5e-06 AD=4.25e-12 AS=4.25e-12 PD=6.7e-06 PS=6.7e-06 NRD=0.085 NRS=0.085 $X=53650 $Y=26800 $D=37
M13 13 8 15 GNDA nmos4 L=2e-05 W=1e-05 AD=5e-12 AS=5e-12 PD=1e-06 PS=1e-06 NRD=0.0425 NRS=0.0425 $X=56875 $Y=68450 $D=37
M14 15 16 17 GNDA nmos4 L=2e-05 W=5e-06 AD=4.25e-12 AS=4.25e-12 PD=6.7e-06 PS=6.7e-06 NRD=0.085 NRS=0.085 $X=59900 $Y=26800 $D=37
M15 15 16 17 GNDA nmos4 L=2e-05 W=5e-06 AD=4.25e-12 AS=4.25e-12 PD=6.7e-06 PS=6.7e-06 NRD=0.085 NRS=0.085 $X=66150 $Y=26800 $D=37
M16 15 16 17 GNDA nmos4 L=2e-05 W=5e-06 AD=4.25e-12 AS=4.25e-12 PD=6.7e-06 PS=6.7e-06 NRD=0.085 NRS=0.085 $X=72400 $Y=26800 $D=37
M17 15 8 13 GNDA nmos4 L=2e-05 W=1e-05 AD=8.5e-12 AS=5e-12 PD=1.17e-05 PS=1e-06 NRD=0.0425 NRS=0.0425 $X=77875 $Y=68450 $D=37
M18 16 16 GNDA GNDA nmos4 L=2e-05 W=5e-06 AD=4.25e-12 AS=4.25e-12 PD=6.7e-06 PS=6.7e-06 NRD=0.085 NRS=0.085 $X=78650 $Y=26800 $D=37
M19 15 16 17 GNDA nmos4 L=2e-05 W=5e-06 AD=4.25e-12 AS=4.25e-12 PD=6.7e-06 PS=6.7e-06 NRD=0.085 NRS=0.085 $X=84900 $Y=26800 $D=37
M20 15 16 17 GNDA nmos4 L=2e-05 W=5e-06 AD=4.25e-12 AS=4.25e-12 PD=6.7e-06 PS=6.7e-06 NRD=0.085 NRS=0.085 $X=91150 $Y=26800 $D=37
M21 8 8 16 GNDA nmos4 L=2e-05 W=1e-05 AD=8.5e-12 AS=8.5e-12 PD=1.17e-05 PS=1.17e-05 NRD=0.0425 NRS=0.0425 $X=100675 $Y=68450 $D=37
M22 7 7 7 VDDA pmos4 L=2e-05 W=4e-06 AD=3.4e-12 AS=3.4e-12 PD=5.7e-06 PS=5.7e-06 NRD=0.10625 NRS=0.10625 $X=13400 $Y=173700 $D=42
M23 7 7 7 VDDA pmos4 L=2e-05 W=4e-06 AD=3.4e-12 AS=3.4e-12 PD=5.7e-06 PS=5.7e-06 NRD=0.10625 NRS=0.10625 $X=155150 $Y=173700 $D=42
M24 VDDA 7 10 VDDA pmos4 L=2e-05 W=4e-06 AD=3.4e-12 AS=3.4e-12 PD=5.7e-06 PS=5.7e-06 NRD=0.10625 NRS=0.10625 $X=29150 $Y=173700 $D=41
M25 VDDA 7 9 VDDA pmos4 L=2e-05 W=4e-06 AD=3.4e-12 AS=3.4e-12 PD=5.7e-06 PS=5.7e-06 NRD=0.10625 NRS=0.10625 $X=34400 $Y=173700 $D=41
M26 VDDA 7 7 VDDA pmos4 L=2e-05 W=4e-06 AD=3.4e-12 AS=3.4e-12 PD=5.7e-06 PS=5.7e-06 NRD=0.10625 NRS=0.10625 $X=50150 $Y=173700 $D=41
M27 VDDA 7 10 VDDA pmos4 L=2e-05 W=4e-06 AD=3.4e-12 AS=3.4e-12 PD=5.7e-06 PS=5.7e-06 NRD=0.10625 NRS=0.10625 $X=55400 $Y=173700 $D=41
M28 VDDA 7 11 VDDA pmos4 L=2e-05 W=4e-06 AD=3.4e-12 AS=3.4e-12 PD=5.7e-06 PS=5.7e-06 NRD=0.10625 NRS=0.10625 $X=71150 $Y=173700 $D=41
M29 VDDA 7 7 VDDA pmos4 L=2e-05 W=4e-06 AD=3.4e-12 AS=3.4e-12 PD=5.7e-06 PS=5.7e-06 NRD=0.10625 NRS=0.10625 $X=76400 $Y=173700 $D=41
M30 VDDA 7 9 VDDA pmos4 L=2e-05 W=4e-06 AD=3.4e-12 AS=3.4e-12 PD=5.7e-06 PS=5.7e-06 NRD=0.10625 NRS=0.10625 $X=92150 $Y=173700 $D=41
M31 VDDA 7 14 VDDA pmos4 L=2e-05 W=4e-06 AD=3.4e-12 AS=3.4e-12 PD=5.7e-06 PS=5.7e-06 NRD=0.10625 NRS=0.10625 $X=97400 $Y=173700 $D=41
M32 VDDA 7 10 VDDA pmos4 L=2e-05 W=4e-06 AD=3.4e-12 AS=3.4e-12 PD=5.7e-06 PS=5.7e-06 NRD=0.10625 NRS=0.10625 $X=113150 $Y=173700 $D=41
M33 VDDA 7 9 VDDA pmos4 L=2e-05 W=4e-06 AD=3.4e-12 AS=3.4e-12 PD=5.7e-06 PS=5.7e-06 NRD=0.10625 NRS=0.10625 $X=118400 $Y=173700 $D=41
M34 12 13 OUT4 VDDA pmos4 L=2e-05 W=4e-06 AD=3.4e-12 AS=3.4e-12 PD=5.7e-06 PS=5.7e-06 NRD=0.10625 NRS=0.10625 $X=118850 $Y=111200 $D=41
M35 VDDA 7 7 VDDA pmos4 L=2e-05 W=4e-06 AD=3.4e-12 AS=3.4e-12 PD=5.7e-06 PS=5.7e-06 NRD=0.10625 NRS=0.10625 $X=134150 $Y=173700 $D=41
M36 VDDA 7 10 VDDA pmos4 L=2e-05 W=4e-06 AD=3.4e-12 AS=3.4e-12 PD=5.7e-06 PS=5.7e-06 NRD=0.10625 NRS=0.10625 $X=139400 $Y=173700 $D=41
C37 GNDA VDDA $[cpolya] $A=1445.4 $P=196.6 $X=144350 $Y=64200 $D=58
X38 13 18 18 VDDA pmos4_CDNS_7807366010317 $T=137800 77200 1 180 $X=131600 $Y=76000
X39 18 8 8 VDDA pmos4_CDNS_7807366010317 $T=137800 83300 1 180 $X=131600 $Y=82100
X43 7 13 13 VDDA pmos4_CDNS_7807366010330 $T=12600 132050 1 0 $X=11400 $Y=109150
X44 14 8 13 VDDA pmos4_CDNS_7807366010330 $T=33850 132050 1 0 $X=32650 $Y=109150
X45 9 OUT1 13 VDDA pmos4_CDNS_7807366010330 $T=55100 132050 1 0 $X=53900 $Y=109150
X46 10 OUT2 13 VDDA pmos4_CDNS_7807366010330 $T=76350 132050 1 0 $X=75150 $Y=109150
X47 11 OUT3 13 VDDA pmos4_CDNS_7807366010330 $T=97600 132050 1 0 $X=96400 $Y=109150
X49 VDDA 11 7 7 ICV_7 $T=13400 194550 1 0 $X=12200 $Y=171650
X50 VDDA 14 11 7 ICV_7 $T=34400 194550 1 0 $X=33200 $Y=171650
X51 VDDA 9 14 7 ICV_7 $T=55400 194550 1 0 $X=54200 $Y=171650
X52 VDDA 10 12 7 ICV_7 $T=76400 194550 1 0 $X=75200 $Y=171650
X53 VDDA 11 7 7 ICV_7 $T=97400 194550 1 0 $X=96200 $Y=171650
X54 VDDA 14 11 7 ICV_7 $T=118400 194550 1 0 $X=117200 $Y=171650
X55 VDDA 9 14 7 ICV_7 $T=139400 194550 1 0 $X=138200 $Y=171650
.ENDS
***************************************
.SUBCKT ICV_17 1
** N=9 EP=1 IP=31 FDC=2
M0 1 1 1 1 pmos4 L=1e-05 W=5e-06 AD=4.25e-12 AS=4.25e-12 PD=6.7e-06 PS=6.7e-06 NRD=0.085 NRS=0.085 $X=0 $Y=-122150 $D=42
M1 1 1 1 1 pmos4 L=1e-05 W=5e-06 AD=4.25e-12 AS=4.25e-12 PD=6.7e-06 PS=6.7e-06 NRD=0.085 NRS=0.085 $X=0 $Y=850 $D=42
.ENDS
***************************************
.SUBCKT P1_C_CDNS_78073660103103
** N=2 EP=0 IP=0 FDC=0
.ENDS
***************************************
.SUBCKT ND_C_CDNS_78073660103124
** N=2 EP=0 IP=0 FDC=0
.ENDS
***************************************
.SUBCKT PD_C_CDNS_78073660103134
** N=1 EP=0 IP=0 FDC=0
.ENDS
***************************************
.SUBCKT ND_C_CDNS_78073660103139
** N=2 EP=0 IP=0 FDC=0
.ENDS
***************************************
.SUBCKT ND_C_CDNS_78073660103131
** N=2 EP=0 IP=0 FDC=0
.ENDS
***************************************
.SUBCKT pmos4_CDNS_780736601037
** N=4 EP=0 IP=0 FDC=0
.ENDS
***************************************
.SUBCKT ICV_13
** N=6 EP=0 IP=8 FDC=0
.ENDS
***************************************
.SUBCKT ICV_14 1 2 3 5 6
** N=8 EP=5 IP=12 FDC=3
M0 2 5 1 1 pmos4 L=4e-06 W=2.5e-05 AD=2.125e-11 AS=2.125e-11 PD=2.67e-05 PS=2.67e-05 NRD=0.017 NRS=0.017 $X=0 $Y=-18050 $D=41
M1 3 6 1 1 pmos4 L=4e-06 W=2.5e-05 AD=2.125e-11 AS=2.125e-11 PD=2.67e-05 PS=2.67e-05 NRD=0.017 NRS=0.017 $X=0 $Y=-11750 $D=41
M2 2 5 1 1 pmos4 L=4e-06 W=2.5e-05 AD=2.125e-11 AS=2.125e-11 PD=2.67e-05 PS=2.67e-05 NRD=0.017 NRS=0.017 $X=0 $Y=-5450 $D=41
.ENDS
***************************************
.SUBCKT ND_C_CDNS_78073660103132
** N=2 EP=0 IP=0 FDC=0
.ENDS
***************************************
.SUBCKT ND_C_CDNS_78073660103130
** N=2 EP=0 IP=0 FDC=0
.ENDS
***************************************
.SUBCKT pmos4_CDNS_780736601038
** N=4 EP=0 IP=0 FDC=0
.ENDS
***************************************
.SUBCKT P1_C_CDNS_78073660103123
** N=2 EP=0 IP=0 FDC=0
.ENDS
***************************************
.SUBCKT rpolyhc_CDNS_780736601031 1 2
** N=3 EP=2 IP=0 FDC=1
R0 1 2 L=5.255e-05 W=2e-06 $[rpolyh] $X=-2000 $Y=2750 $D=18
.ENDS
***************************************
.SUBCKT ICV_11 1 2 3
*.CALIBRE ICV_CELL 9
** N=3 EP=3 IP=4 FDC=2
X0 1 2 vert10_4 $T=0 0 0 0 $X=0 $Y=0
X1 3 2 vert10_4 $T=16900 0 0 0 $X=16900 $Y=0
.ENDS
***************************************
.SUBCKT ICV_12 1 2 3 4 5
*.CALIBRE ICV_CELL 9
** N=5 EP=5 IP=6 FDC=4
X0 1 2 3 ICV_11 $T=0 0 0 0 $X=0 $Y=0
X1 4 2 5 ICV_11 $T=33800 0 0 0 $X=33800 $Y=0
.ENDS
***************************************
.SUBCKT ICV_10 1 2 3 4
*.CALIBRE ICV_CELL 9
** N=5 EP=4 IP=6 FDC=2
X0 1 2 rpolyhc_CDNS_780736601031 $T=-18050 0 0 0 $X=-25800 $Y=-5750
X1 3 4 rpolyhc_CDNS_780736601031 $T=0 0 0 0 $X=-7750 $Y=-5750
.ENDS
***************************************
.SUBCKT ICV_9 1 2 3 4
*.CALIBRE ICV_CELL 9
** N=5 EP=4 IP=6 FDC=2
X0 1 2 rpolyhc_CDNS_780736601031 $T=0 0 0 0 $X=-7750 $Y=-5750
X1 3 4 rpolyhc_CDNS_780736601031 $T=18050 0 0 0 $X=10300 $Y=-5750
.ENDS
***************************************
.SUBCKT fecg_bandgap3_layout BG_REF VDDA GNDA BIAS
** N=57 EP=4 IP=644 FDC=249
R0 29 29 L=5e-06 W=8e-07 $[rpolyh] $X=41700 $Y=127800 $D=18
D1 GNDA VDDA p_nwd AREA=30907.1 PJ=704.2 $X=4250 $Y=202850 $D=87
D2 GNDA GNDA p_nwd AREA=4227.61 PJ=279.45 $X=4275 $Y=135225 $D=87
D3 GNDA 6 p_nwd AREA=7338.63 PJ=343.3 $X=123850 $Y=119100 $D=87
D4 GNDA 7 p_nwd AREA=1888.05 PJ=175 $X=193000 $Y=211450 $D=87
D5 GNDA GNDA p_nwd AREA=17415.8 PJ=546.1 $X=239000 $Y=120500 $D=87
M6 BIAS BIAS BIAS GNDA nmos4 L=1e-05 W=5e-06 AD=4.25e-12 AS=4.25e-12 PD=6.7e-06 PS=6.7e-06 NRD=0.085 NRS=0.085 $X=203275 $Y=323775 $D=38
M7 BIAS BIAS BIAS GNDA nmos4 L=1e-05 W=5e-06 AD=4.25e-12 AS=4.25e-12 PD=6.7e-06 PS=6.7e-06 NRD=0.085 NRS=0.085 $X=203275 $Y=355025 $D=38
M8 9 9 GNDA GNDA nmos4 L=1e-05 W=1e-05 AD=8.5e-12 AS=8.5e-12 PD=1.17e-05 PS=1.17e-05 NRD=0.0425 NRS=0.0425 $X=84725 $Y=134125 $D=37
M9 10 9 GNDA GNDA nmos4 L=1e-05 W=1e-05 AD=8.5e-12 AS=8.5e-12 PD=1.17e-05 PS=1.17e-05 NRD=0.0425 NRS=0.0425 $X=84725 $Y=147525 $D=37
M10 10 9 GNDA GNDA nmos4 L=1e-05 W=1e-05 AD=8.5e-12 AS=8.5e-12 PD=1.17e-05 PS=1.17e-05 NRD=0.0425 NRS=0.0425 $X=97525 $Y=134125 $D=37
M11 9 9 GNDA GNDA nmos4 L=1e-05 W=1e-05 AD=8.5e-12 AS=8.5e-12 PD=1.17e-05 PS=1.17e-05 NRD=0.0425 NRS=0.0425 $X=97525 $Y=147525 $D=37
M12 GNDA BIAS BIAS GNDA nmos4 L=1e-05 W=5e-06 AD=4.25e-12 AS=4.25e-12 PD=6.7e-06 PS=6.7e-06 NRD=0.085 NRS=0.085 $X=203275 $Y=330025 $D=37
M13 GNDA BIAS 5 GNDA nmos4 L=1e-05 W=5e-06 AD=4.25e-12 AS=4.25e-12 PD=6.7e-06 PS=6.7e-06 NRD=0.085 NRS=0.085 $X=203275 $Y=336275 $D=37
M14 GNDA BIAS BIAS GNDA nmos4 L=1e-05 W=5e-06 AD=4.25e-12 AS=4.25e-12 PD=6.7e-06 PS=6.7e-06 NRD=0.085 NRS=0.085 $X=203275 $Y=342525 $D=37
M15 GNDA BIAS 5 GNDA nmos4 L=1e-05 W=5e-06 AD=4.25e-12 AS=4.25e-12 PD=6.7e-06 PS=6.7e-06 NRD=0.085 NRS=0.085 $X=203275 $Y=348775 $D=37
M16 11 12 GNDA GNDA nmos4 L=1e-05 W=1e-05 AD=8.5e-12 AS=8.5e-12 PD=1.17e-05 PS=1.17e-05 NRD=0.0425 NRS=0.0425 $X=203625 $Y=278250 $D=37
M17 12 12 GNDA GNDA nmos4 L=1e-05 W=1e-05 AD=8.5e-12 AS=8.5e-12 PD=1.17e-05 PS=1.17e-05 NRD=0.0425 NRS=0.0425 $X=203625 $Y=290550 $D=37
M18 12 12 GNDA GNDA nmos4 L=1e-05 W=1e-05 AD=8.5e-12 AS=8.5e-12 PD=1.17e-05 PS=1.17e-05 NRD=0.0425 NRS=0.0425 $X=217125 $Y=278250 $D=37
M19 11 12 GNDA GNDA nmos4 L=1e-05 W=1e-05 AD=8.5e-12 AS=8.5e-12 PD=1.17e-05 PS=1.17e-05 NRD=0.0425 NRS=0.0425 $X=217125 $Y=290550 $D=37
M20 14 10 GNDA GNDA nmos4 L=1e-06 W=5e-06 AD=2.5e-12 AS=4.25e-12 PD=1e-06 PS=6.7e-06 NRD=0.085 NRS=0.085 $X=219775 $Y=173375 $D=37
M21 BG_REF 11 14 GNDA nmos4 L=1e-05 W=5e-06 AD=4.25e-12 AS=4.25e-12 PD=6.7e-06 PS=6.7e-06 NRD=0.085 NRS=0.085 $X=220000 $Y=190850 $D=37
M22 GNDA 10 14 GNDA nmos4 L=1e-06 W=5e-06 AD=4.25e-12 AS=2.5e-12 PD=6.7e-06 PS=1e-06 NRD=0.085 NRS=0.085 $X=221775 $Y=173375 $D=37
M23 8 8 GNDA GNDA nmos4 L=1e-05 W=5e-07 AD=5.9e-13 AS=5.9e-13 PD=2.7e-06 PS=2.7e-06 NRD=0.85 NRS=0.85 $X=236350 $Y=232050 $D=37
M24 VDDA VDDA VDDA VDDA pmos4 L=1e-05 W=5e-06 AD=4.25e-12 AS=4.25e-12 PD=6.7e-06 PS=6.7e-06 NRD=0.085 NRS=0.085 $X=42725 $Y=219700 $D=42
M25 VDDA VDDA VDDA VDDA pmos4 L=1e-05 W=5e-06 AD=4.25e-12 AS=4.25e-12 PD=6.7e-06 PS=6.7e-06 NRD=0.085 NRS=0.085 $X=42725 $Y=347800 $D=42
M26 VDDA VDDA VDDA VDDA pmos4 L=1e-05 W=5e-06 AD=4.25e-12 AS=4.25e-12 PD=6.7e-06 PS=6.7e-06 NRD=0.085 NRS=0.085 $X=55025 $Y=219700 $D=42
M27 VDDA VDDA VDDA VDDA pmos4 L=1e-05 W=5e-06 AD=4.25e-12 AS=4.25e-12 PD=6.7e-06 PS=6.7e-06 NRD=0.085 NRS=0.085 $X=55025 $Y=347800 $D=42
M28 VDDA VDDA VDDA VDDA pmos4 L=1e-05 W=5e-06 AD=4.25e-12 AS=4.25e-12 PD=6.7e-06 PS=6.7e-06 NRD=0.085 NRS=0.085 $X=67325 $Y=219700 $D=42
M29 VDDA VDDA VDDA VDDA pmos4 L=1e-05 W=5e-06 AD=4.25e-12 AS=4.25e-12 PD=6.7e-06 PS=6.7e-06 NRD=0.085 NRS=0.085 $X=67325 $Y=347800 $D=42
M30 VDDA VDDA VDDA VDDA pmos4 L=1e-05 W=5e-06 AD=4.25e-12 AS=4.25e-12 PD=6.7e-06 PS=6.7e-06 NRD=0.085 NRS=0.085 $X=79625 $Y=219700 $D=42
M31 VDDA VDDA VDDA VDDA pmos4 L=1e-05 W=5e-06 AD=4.25e-12 AS=4.25e-12 PD=6.7e-06 PS=6.7e-06 NRD=0.085 NRS=0.085 $X=79625 $Y=347800 $D=42
M32 VDDA VDDA VDDA VDDA pmos4 L=1e-05 W=5e-06 AD=4.25e-12 AS=4.25e-12 PD=6.7e-06 PS=6.7e-06 NRD=0.085 NRS=0.085 $X=91925 $Y=219700 $D=42
M33 VDDA VDDA VDDA VDDA pmos4 L=1e-05 W=5e-06 AD=4.25e-12 AS=4.25e-12 PD=6.7e-06 PS=6.7e-06 NRD=0.085 NRS=0.085 $X=91925 $Y=347800 $D=42
M34 VDDA VDDA VDDA VDDA pmos4 L=1e-05 W=5e-06 AD=4.25e-12 AS=4.25e-12 PD=6.7e-06 PS=6.7e-06 NRD=0.085 NRS=0.085 $X=104225 $Y=219700 $D=42
M35 VDDA VDDA VDDA VDDA pmos4 L=1e-05 W=5e-06 AD=4.25e-12 AS=4.25e-12 PD=6.7e-06 PS=6.7e-06 NRD=0.085 NRS=0.085 $X=104225 $Y=347800 $D=42
M36 VDDA VDDA VDDA VDDA pmos4 L=1e-05 W=5e-06 AD=4.25e-12 AS=4.25e-12 PD=6.7e-06 PS=6.7e-06 NRD=0.085 NRS=0.085 $X=116525 $Y=219700 $D=42
M37 VDDA VDDA VDDA VDDA pmos4 L=1e-05 W=5e-06 AD=4.25e-12 AS=4.25e-12 PD=6.7e-06 PS=6.7e-06 NRD=0.085 NRS=0.085 $X=116525 $Y=347800 $D=42
M38 VDDA VDDA VDDA VDDA pmos4 L=1e-05 W=5e-06 AD=4.25e-12 AS=4.25e-12 PD=6.7e-06 PS=6.7e-06 NRD=0.085 NRS=0.085 $X=128825 $Y=219700 $D=42
M39 VDDA VDDA VDDA VDDA pmos4 L=1e-05 W=5e-06 AD=4.25e-12 AS=4.25e-12 PD=6.7e-06 PS=6.7e-06 NRD=0.085 NRS=0.085 $X=128825 $Y=347800 $D=42
M40 6 6 6 6 pmos4 L=4e-06 W=2.5e-05 AD=2.125e-11 AS=2.125e-11 PD=2.67e-05 PS=2.67e-05 NRD=0.017 NRS=0.017 $X=139025 $Y=130450 $D=42
M41 6 6 6 6 pmos4 L=4e-06 W=2.5e-05 AD=2.125e-11 AS=2.125e-11 PD=2.67e-05 PS=2.67e-05 NRD=0.017 NRS=0.017 $X=139025 $Y=163350 $D=42
M42 VDDA VDDA VDDA VDDA pmos4 L=1e-05 W=5e-06 AD=4.25e-12 AS=4.25e-12 PD=6.7e-06 PS=6.7e-06 NRD=0.085 NRS=0.085 $X=141125 $Y=219700 $D=42
M43 VDDA VDDA VDDA VDDA pmos4 L=1e-05 W=5e-06 AD=4.25e-12 AS=4.25e-12 PD=6.7e-06 PS=6.7e-06 NRD=0.085 NRS=0.085 $X=141125 $Y=347800 $D=42
M44 6 6 6 6 pmos4 L=4e-06 W=2.5e-05 AD=2.125e-11 AS=2.125e-11 PD=2.67e-05 PS=2.67e-05 NRD=0.017 NRS=0.017 $X=195725 $Y=130450 $D=42
M45 6 6 6 6 pmos4 L=4e-06 W=2.5e-05 AD=2.125e-11 AS=2.125e-11 PD=2.67e-05 PS=2.67e-05 NRD=0.017 NRS=0.017 $X=195725 $Y=163350 $D=42
M46 7 7 7 7 pmos4 L=3.5e-07 W=1e-05 AD=8.5e-12 AS=8.5e-12 PD=1.17e-05 PS=1.17e-05 NRD=0.0425 NRS=0.0425 $X=208175 $Y=222800 $D=42
M47 7 7 7 7 pmos4 L=3.5e-07 W=1e-05 AD=8.5e-12 AS=8.5e-12 PD=1.17e-05 PS=1.17e-05 NRD=0.0425 NRS=0.0425 $X=208175 $Y=238950 $D=42
M48 7 7 7 7 pmos4 L=3.5e-07 W=1e-05 AD=8.5e-12 AS=8.5e-12 PD=1.17e-05 PS=1.17e-05 NRD=0.0425 NRS=0.0425 $X=216125 $Y=222800 $D=42
M49 7 7 7 7 pmos4 L=3.5e-07 W=1e-05 AD=8.5e-12 AS=8.5e-12 PD=1.17e-05 PS=1.17e-05 NRD=0.0425 NRS=0.0425 $X=216125 $Y=238950 $D=42
M50 VDDA 5 BG_REF VDDA pmos4 L=1e-05 W=5e-06 AD=4.25e-12 AS=4.25e-12 PD=6.7e-06 PS=6.7e-06 NRD=0.085 NRS=0.085 $X=42725 $Y=238000 $D=41
M51 VDDA 5 BG_REF VDDA pmos4 L=1e-05 W=5e-06 AD=4.25e-12 AS=4.25e-12 PD=6.7e-06 PS=6.7e-06 NRD=0.085 NRS=0.085 $X=42725 $Y=256300 $D=41
M52 VDDA 5 BG_REF VDDA pmos4 L=1e-05 W=5e-06 AD=4.25e-12 AS=4.25e-12 PD=6.7e-06 PS=6.7e-06 NRD=0.085 NRS=0.085 $X=42725 $Y=274600 $D=41
M53 VDDA 5 BG_REF VDDA pmos4 L=1e-05 W=5e-06 AD=4.25e-12 AS=4.25e-12 PD=6.7e-06 PS=6.7e-06 NRD=0.085 NRS=0.085 $X=42725 $Y=292900 $D=41
M54 VDDA 5 BG_REF VDDA pmos4 L=1e-05 W=5e-06 AD=4.25e-12 AS=4.25e-12 PD=6.7e-06 PS=6.7e-06 NRD=0.085 NRS=0.085 $X=42725 $Y=311200 $D=41
M55 VDDA 5 BG_REF VDDA pmos4 L=1e-05 W=5e-06 AD=4.25e-12 AS=4.25e-12 PD=6.7e-06 PS=6.7e-06 NRD=0.085 NRS=0.085 $X=42725 $Y=329500 $D=41
M56 VDDA 5 BG_REF VDDA pmos4 L=1e-05 W=5e-06 AD=4.25e-12 AS=4.25e-12 PD=6.7e-06 PS=6.7e-06 NRD=0.085 NRS=0.085 $X=55025 $Y=238000 $D=41
M57 VDDA 5 6 VDDA pmos4 L=1e-05 W=5e-06 AD=4.25e-12 AS=4.25e-12 PD=6.7e-06 PS=6.7e-06 NRD=0.085 NRS=0.085 $X=55025 $Y=256300 $D=41
M58 VDDA 5 BG_REF VDDA pmos4 L=1e-05 W=5e-06 AD=4.25e-12 AS=4.25e-12 PD=6.7e-06 PS=6.7e-06 NRD=0.085 NRS=0.085 $X=55025 $Y=274600 $D=41
M59 VDDA 5 BG_REF VDDA pmos4 L=1e-05 W=5e-06 AD=4.25e-12 AS=4.25e-12 PD=6.7e-06 PS=6.7e-06 NRD=0.085 NRS=0.085 $X=55025 $Y=292900 $D=41
M60 VDDA 5 6 VDDA pmos4 L=1e-05 W=5e-06 AD=4.25e-12 AS=4.25e-12 PD=6.7e-06 PS=6.7e-06 NRD=0.085 NRS=0.085 $X=55025 $Y=311200 $D=41
M61 VDDA 5 BG_REF VDDA pmos4 L=1e-05 W=5e-06 AD=4.25e-12 AS=4.25e-12 PD=6.7e-06 PS=6.7e-06 NRD=0.085 NRS=0.085 $X=55025 $Y=329500 $D=41
M62 VDDA 5 BG_REF VDDA pmos4 L=1e-05 W=5e-06 AD=4.25e-12 AS=4.25e-12 PD=6.7e-06 PS=6.7e-06 NRD=0.085 NRS=0.085 $X=67325 $Y=238000 $D=41
M63 VDDA 5 6 VDDA pmos4 L=1e-05 W=5e-06 AD=4.25e-12 AS=4.25e-12 PD=6.7e-06 PS=6.7e-06 NRD=0.085 NRS=0.085 $X=67325 $Y=256300 $D=41
M64 VDDA 5 6 VDDA pmos4 L=1e-05 W=5e-06 AD=4.25e-12 AS=4.25e-12 PD=6.7e-06 PS=6.7e-06 NRD=0.085 NRS=0.085 $X=67325 $Y=274600 $D=41
M65 VDDA 5 6 VDDA pmos4 L=1e-05 W=5e-06 AD=4.25e-12 AS=4.25e-12 PD=6.7e-06 PS=6.7e-06 NRD=0.085 NRS=0.085 $X=67325 $Y=292900 $D=41
M66 VDDA 5 6 VDDA pmos4 L=1e-05 W=5e-06 AD=4.25e-12 AS=4.25e-12 PD=6.7e-06 PS=6.7e-06 NRD=0.085 NRS=0.085 $X=67325 $Y=311200 $D=41
M67 VDDA 5 BG_REF VDDA pmos4 L=1e-05 W=5e-06 AD=4.25e-12 AS=4.25e-12 PD=6.7e-06 PS=6.7e-06 NRD=0.085 NRS=0.085 $X=67325 $Y=329500 $D=41
M68 VDDA 5 BG_REF VDDA pmos4 L=1e-05 W=5e-06 AD=4.25e-12 AS=4.25e-12 PD=6.7e-06 PS=6.7e-06 NRD=0.085 NRS=0.085 $X=79625 $Y=238000 $D=41
M69 VDDA 5 6 VDDA pmos4 L=1e-05 W=5e-06 AD=4.25e-12 AS=4.25e-12 PD=6.7e-06 PS=6.7e-06 NRD=0.085 NRS=0.085 $X=79625 $Y=256300 $D=41
M70 VDDA 5 5 VDDA pmos4 L=1e-05 W=5e-06 AD=4.25e-12 AS=4.25e-12 PD=6.7e-06 PS=6.7e-06 NRD=0.085 NRS=0.085 $X=79625 $Y=274600 $D=41
M71 VDDA 5 6 VDDA pmos4 L=1e-05 W=5e-06 AD=4.25e-12 AS=4.25e-12 PD=6.7e-06 PS=6.7e-06 NRD=0.085 NRS=0.085 $X=79625 $Y=292900 $D=41
M72 VDDA 5 6 VDDA pmos4 L=1e-05 W=5e-06 AD=4.25e-12 AS=4.25e-12 PD=6.7e-06 PS=6.7e-06 NRD=0.085 NRS=0.085 $X=79625 $Y=311200 $D=41
M73 VDDA 5 BG_REF VDDA pmos4 L=1e-05 W=5e-06 AD=4.25e-12 AS=4.25e-12 PD=6.7e-06 PS=6.7e-06 NRD=0.085 NRS=0.085 $X=79625 $Y=329500 $D=41
M74 VDDA 5 BG_REF VDDA pmos4 L=1e-05 W=5e-06 AD=4.25e-12 AS=4.25e-12 PD=6.7e-06 PS=6.7e-06 NRD=0.085 NRS=0.085 $X=91925 $Y=238000 $D=41
M75 VDDA 5 6 VDDA pmos4 L=1e-05 W=5e-06 AD=4.25e-12 AS=4.25e-12 PD=6.7e-06 PS=6.7e-06 NRD=0.085 NRS=0.085 $X=91925 $Y=256300 $D=41
M76 VDDA 5 8 VDDA pmos4 L=1e-05 W=5e-06 AD=4.25e-12 AS=4.25e-12 PD=6.7e-06 PS=6.7e-06 NRD=0.085 NRS=0.085 $X=91925 $Y=274600 $D=41
M77 VDDA 5 7 VDDA pmos4 L=1e-05 W=5e-06 AD=4.25e-12 AS=4.25e-12 PD=6.7e-06 PS=6.7e-06 NRD=0.085 NRS=0.085 $X=91925 $Y=292900 $D=41
M78 VDDA 5 6 VDDA pmos4 L=1e-05 W=5e-06 AD=4.25e-12 AS=4.25e-12 PD=6.7e-06 PS=6.7e-06 NRD=0.085 NRS=0.085 $X=91925 $Y=311200 $D=41
M79 VDDA 5 BG_REF VDDA pmos4 L=1e-05 W=5e-06 AD=4.25e-12 AS=4.25e-12 PD=6.7e-06 PS=6.7e-06 NRD=0.085 NRS=0.085 $X=91925 $Y=329500 $D=41
M80 VDDA 5 BG_REF VDDA pmos4 L=1e-05 W=5e-06 AD=4.25e-12 AS=4.25e-12 PD=6.7e-06 PS=6.7e-06 NRD=0.085 NRS=0.085 $X=104225 $Y=238000 $D=41
M81 VDDA 5 6 VDDA pmos4 L=1e-05 W=5e-06 AD=4.25e-12 AS=4.25e-12 PD=6.7e-06 PS=6.7e-06 NRD=0.085 NRS=0.085 $X=104225 $Y=256300 $D=41
M82 VDDA 5 6 VDDA pmos4 L=1e-05 W=5e-06 AD=4.25e-12 AS=4.25e-12 PD=6.7e-06 PS=6.7e-06 NRD=0.085 NRS=0.085 $X=104225 $Y=274600 $D=41
M83 VDDA 5 5 VDDA pmos4 L=1e-05 W=5e-06 AD=4.25e-12 AS=4.25e-12 PD=6.7e-06 PS=6.7e-06 NRD=0.085 NRS=0.085 $X=104225 $Y=292900 $D=41
M84 VDDA 5 6 VDDA pmos4 L=1e-05 W=5e-06 AD=4.25e-12 AS=4.25e-12 PD=6.7e-06 PS=6.7e-06 NRD=0.085 NRS=0.085 $X=104225 $Y=311200 $D=41
M85 VDDA 5 BG_REF VDDA pmos4 L=1e-05 W=5e-06 AD=4.25e-12 AS=4.25e-12 PD=6.7e-06 PS=6.7e-06 NRD=0.085 NRS=0.085 $X=104225 $Y=329500 $D=41
M86 VDDA 5 BG_REF VDDA pmos4 L=1e-05 W=5e-06 AD=4.25e-12 AS=4.25e-12 PD=6.7e-06 PS=6.7e-06 NRD=0.085 NRS=0.085 $X=116525 $Y=238000 $D=41
M87 VDDA 5 6 VDDA pmos4 L=1e-05 W=5e-06 AD=4.25e-12 AS=4.25e-12 PD=6.7e-06 PS=6.7e-06 NRD=0.085 NRS=0.085 $X=116525 $Y=256300 $D=41
M88 VDDA 5 6 VDDA pmos4 L=1e-05 W=5e-06 AD=4.25e-12 AS=4.25e-12 PD=6.7e-06 PS=6.7e-06 NRD=0.085 NRS=0.085 $X=116525 $Y=274600 $D=41
M89 VDDA 5 6 VDDA pmos4 L=1e-05 W=5e-06 AD=4.25e-12 AS=4.25e-12 PD=6.7e-06 PS=6.7e-06 NRD=0.085 NRS=0.085 $X=116525 $Y=292900 $D=41
M90 VDDA 5 6 VDDA pmos4 L=1e-05 W=5e-06 AD=4.25e-12 AS=4.25e-12 PD=6.7e-06 PS=6.7e-06 NRD=0.085 NRS=0.085 $X=116525 $Y=311200 $D=41
M91 VDDA 5 BG_REF VDDA pmos4 L=1e-05 W=5e-06 AD=4.25e-12 AS=4.25e-12 PD=6.7e-06 PS=6.7e-06 NRD=0.085 NRS=0.085 $X=116525 $Y=329500 $D=41
M92 VDDA 5 BG_REF VDDA pmos4 L=1e-05 W=5e-06 AD=4.25e-12 AS=4.25e-12 PD=6.7e-06 PS=6.7e-06 NRD=0.085 NRS=0.085 $X=128825 $Y=238000 $D=41
M93 VDDA 5 6 VDDA pmos4 L=1e-05 W=5e-06 AD=4.25e-12 AS=4.25e-12 PD=6.7e-06 PS=6.7e-06 NRD=0.085 NRS=0.085 $X=128825 $Y=256300 $D=41
M94 VDDA 5 BG_REF VDDA pmos4 L=1e-05 W=5e-06 AD=4.25e-12 AS=4.25e-12 PD=6.7e-06 PS=6.7e-06 NRD=0.085 NRS=0.085 $X=128825 $Y=274600 $D=41
M95 VDDA 5 BG_REF VDDA pmos4 L=1e-05 W=5e-06 AD=4.25e-12 AS=4.25e-12 PD=6.7e-06 PS=6.7e-06 NRD=0.085 NRS=0.085 $X=128825 $Y=292900 $D=41
M96 VDDA 5 6 VDDA pmos4 L=1e-05 W=5e-06 AD=4.25e-12 AS=4.25e-12 PD=6.7e-06 PS=6.7e-06 NRD=0.085 NRS=0.085 $X=128825 $Y=311200 $D=41
M97 VDDA 5 BG_REF VDDA pmos4 L=1e-05 W=5e-06 AD=4.25e-12 AS=4.25e-12 PD=6.7e-06 PS=6.7e-06 NRD=0.085 NRS=0.085 $X=128825 $Y=329500 $D=41
M98 VDDA 5 BG_REF VDDA pmos4 L=1e-05 W=5e-06 AD=4.25e-12 AS=4.25e-12 PD=6.7e-06 PS=6.7e-06 NRD=0.085 NRS=0.085 $X=141125 $Y=238000 $D=41
M99 VDDA 5 BG_REF VDDA pmos4 L=1e-05 W=5e-06 AD=4.25e-12 AS=4.25e-12 PD=6.7e-06 PS=6.7e-06 NRD=0.085 NRS=0.085 $X=141125 $Y=256300 $D=41
M100 VDDA 5 BG_REF VDDA pmos4 L=1e-05 W=5e-06 AD=4.25e-12 AS=4.25e-12 PD=6.7e-06 PS=6.7e-06 NRD=0.085 NRS=0.085 $X=141125 $Y=274600 $D=41
M101 VDDA 5 BG_REF VDDA pmos4 L=1e-05 W=5e-06 AD=4.25e-12 AS=4.25e-12 PD=6.7e-06 PS=6.7e-06 NRD=0.085 NRS=0.085 $X=141125 $Y=292900 $D=41
M102 VDDA 5 BG_REF VDDA pmos4 L=1e-05 W=5e-06 AD=4.25e-12 AS=4.25e-12 PD=6.7e-06 PS=6.7e-06 NRD=0.085 NRS=0.085 $X=141125 $Y=311200 $D=41
M103 VDDA 5 BG_REF VDDA pmos4 L=1e-05 W=5e-06 AD=4.25e-12 AS=4.25e-12 PD=6.7e-06 PS=6.7e-06 NRD=0.085 NRS=0.085 $X=141125 $Y=329500 $D=41
M104 6 13 10 6 pmos4 L=4e-06 W=2.5e-05 AD=2.125e-11 AS=2.125e-11 PD=2.67e-05 PS=2.67e-05 NRD=0.017 NRS=0.017 $X=164225 $Y=130450 $D=41
M105 6 15 9 6 pmos4 L=4e-06 W=2.5e-05 AD=2.125e-11 AS=2.125e-11 PD=2.67e-05 PS=2.67e-05 NRD=0.017 NRS=0.017 $X=164225 $Y=163350 $D=41
M106 6 13 10 6 pmos4 L=4e-06 W=2.5e-05 AD=2.125e-11 AS=2.125e-11 PD=2.67e-05 PS=2.67e-05 NRD=0.017 NRS=0.017 $X=189425 $Y=130450 $D=41
M107 6 15 9 6 pmos4 L=4e-06 W=2.5e-05 AD=2.125e-11 AS=2.125e-11 PD=2.67e-05 PS=2.67e-05 NRD=0.017 NRS=0.017 $X=189425 $Y=163350 $D=41
M108 12 BG_REF 7 7 pmos4 L=3.5e-07 W=1e-05 AD=8.5e-12 AS=8.5e-12 PD=1.17e-05 PS=1.17e-05 NRD=0.0425 NRS=0.0425 $X=210825 $Y=222800 $D=41
M109 11 8 7 7 pmos4 L=3.5e-07 W=1e-05 AD=8.5e-12 AS=8.5e-12 PD=1.17e-05 PS=1.17e-05 NRD=0.0425 NRS=0.0425 $X=210825 $Y=238950 $D=41
M110 11 8 7 7 pmos4 L=3.5e-07 W=1e-05 AD=8.5e-12 AS=8.5e-12 PD=1.17e-05 PS=1.17e-05 NRD=0.0425 NRS=0.0425 $X=213475 $Y=222800 $D=41
M111 12 BG_REF 7 7 pmos4 L=3.5e-07 W=1e-05 AD=8.5e-12 AS=8.5e-12 PD=1.17e-05 PS=1.17e-05 NRD=0.0425 NRS=0.0425 $X=213475 $Y=238950 $D=41
C112 BG_REF 10 $[cpolya] $A=3466.12 $P=235.5 $X=7425 $Y=137575 $D=58
X136 GNDA GNDA vert10_4 $T=386925 249650 1 0 $X=386925 $Y=232850
X137 GNDA GNDA vert10_4 $T=386925 268350 1 0 $X=386925 $Y=251550
X138 GNDA GNDA vert10_4 $T=386925 287050 1 0 $X=386925 $Y=270250
X139 GNDA GNDA vert10_4 $T=386925 305750 1 0 $X=386925 $Y=288950
X140 GNDA GNDA vert10_4 $T=386925 324450 1 0 $X=386925 $Y=307650
X141 GNDA GNDA vert10_4 $T=386925 343150 1 0 $X=386925 $Y=326350
X142 GNDA GNDA vert10_4 $T=386925 361850 1 0 $X=386925 $Y=345050
X143 VDDA ICV_17 $T=41275 219700 0 90 $X=28375 $Y=218500
X144 VDDA ICV_17 $T=41275 238000 0 90 $X=28375 $Y=236800
X145 VDDA ICV_17 $T=41275 256300 0 90 $X=28375 $Y=255100
X146 VDDA ICV_17 $T=41275 274600 0 90 $X=28375 $Y=273400
X147 VDDA ICV_17 $T=41275 292900 0 90 $X=28375 $Y=291700
X148 VDDA ICV_17 $T=41275 311200 0 90 $X=28375 $Y=310000
X149 VDDA ICV_17 $T=41275 329500 0 90 $X=28375 $Y=328300
X150 VDDA ICV_17 $T=41275 347800 0 90 $X=28375 $Y=346600
X253 6 9 10 15 13 ICV_14 $T=143875 155450 1 270 $X=136975 $Y=129250
X254 6 10 9 13 15 ICV_14 $T=143875 188350 1 270 $X=136975 $Y=162150
X255 6 9 10 15 13 ICV_14 $T=169075 155450 1 270 $X=162175 $Y=129250
X256 6 10 9 13 15 ICV_14 $T=169075 188350 1 270 $X=162175 $Y=162150
X274 33 17 rpolyhc_CDNS_780736601031 $T=248275 127775 0 0 $X=240525 $Y=122025
X275 30 13 rpolyhc_CDNS_780736601031 $T=256825 146275 1 180 $X=240525 $Y=140525
X276 36 15 rpolyhc_CDNS_780736601031 $T=248275 177775 1 0 $X=240525 $Y=159025
X277 BG_REF 16 rpolyhc_CDNS_780736601031 $T=248275 183275 0 0 $X=240525 $Y=177525
X278 BG_REF 31 rpolyhc_CDNS_780736601031 $T=248275 214775 1 0 $X=240525 $Y=196025
X279 17 35 rpolyhc_CDNS_780736601031 $T=266325 146275 0 0 $X=258575 $Y=140525
X280 21 15 rpolyhc_CDNS_780736601031 $T=274875 177775 0 180 $X=258575 $Y=159025
X281 35 36 rpolyhc_CDNS_780736601031 $T=284375 164775 0 0 $X=276625 $Y=159025
X282 44 39 rpolyhc_CDNS_780736601031 $T=310975 127775 1 180 $X=294675 $Y=122025
X283 GNDA GNDA rpolyhc_CDNS_780736601031 $T=320475 127775 0 0 $X=312725 $Y=122025
X284 22 42 rpolyhc_CDNS_780736601031 $T=329025 159275 0 180 $X=312725 $Y=140525
X285 42 44 rpolyhc_CDNS_780736601031 $T=338525 140775 1 0 $X=330775 $Y=122025
X286 23 22 rpolyhc_CDNS_780736601031 $T=347075 164775 1 180 $X=330775 $Y=159025
X287 43 24 rpolyhc_CDNS_780736601031 $T=338525 183275 0 0 $X=330775 $Y=177525
X288 55 46 rpolyhc_CDNS_780736601031 $T=365125 127775 1 180 $X=348825 $Y=122025
X289 47 48 rpolyhc_CDNS_780736601031 $T=356575 164775 0 0 $X=348825 $Y=159025
X290 27 51 rpolyhc_CDNS_780736601031 $T=383175 140775 0 180 $X=366875 $Y=122025
X291 53 55 rpolyhc_CDNS_780736601031 $T=392675 140775 1 0 $X=384925 $Y=122025
X292 52 56 rpolyhc_CDNS_780736601031 $T=392675 196275 1 0 $X=384925 $Y=177525
X293 GNDA GNDA GNDA GNDA GNDA ICV_12 $T=251725 249650 1 0 $X=251725 $Y=232850
X294 GNDA GNDA 26 26 26 ICV_12 $T=251725 268350 1 0 $X=251725 $Y=251550
X295 GNDA GNDA 26 26 26 ICV_12 $T=251725 287050 1 0 $X=251725 $Y=270250
X296 GNDA GNDA 26 26 26 ICV_12 $T=251725 305750 1 0 $X=251725 $Y=288950
X297 GNDA GNDA 26 26 GNDA ICV_12 $T=251725 324450 1 0 $X=251725 $Y=307650
X298 GNDA GNDA 26 26 26 ICV_12 $T=251725 343150 1 0 $X=251725 $Y=326350
X299 GNDA GNDA GNDA GNDA GNDA ICV_12 $T=251725 361850 1 0 $X=251725 $Y=345050
X300 GNDA GNDA GNDA GNDA GNDA ICV_12 $T=319325 249650 1 0 $X=319325 $Y=232850
X301 GNDA GNDA 26 26 26 ICV_12 $T=319325 268350 1 0 $X=319325 $Y=251550
X302 26 GNDA 26 26 26 ICV_12 $T=319325 287050 1 0 $X=319325 $Y=270250
X303 13 GNDA 26 26 26 ICV_12 $T=319325 305750 1 0 $X=319325 $Y=288950
X304 26 GNDA GNDA 26 26 ICV_12 $T=319325 324450 1 0 $X=319325 $Y=307650
X305 26 GNDA 26 26 26 ICV_12 $T=319325 343150 1 0 $X=319325 $Y=326350
X306 GNDA GNDA GNDA GNDA GNDA ICV_12 $T=319325 361850 1 0 $X=319325 $Y=345050
X307 20 33 32 30 ICV_10 $T=274875 140775 0 180 $X=258575 $Y=122025
X308 48 20 38 32 ICV_10 $T=292925 159275 0 180 $X=276625 $Y=140525
X309 50 21 39 38 ICV_10 $T=310975 164775 1 180 $X=294675 $Y=159025
X310 51 23 46 47 ICV_10 $T=347075 146275 1 180 $X=330775 $Y=140525
X311 56 27 54 53 ICV_10 $T=383175 159275 0 180 $X=366875 $Y=140525
X312 57 54 26 50 ICV_10 $T=383175 177775 0 180 $X=366875 $Y=159025
X313 31 18 34 19 ICV_9 $T=266325 196275 1 0 $X=258575 $Y=177525
X314 16 34 18 37 ICV_9 $T=266325 201775 0 0 $X=258575 $Y=196025
X315 37 43 40 41 ICV_9 $T=302425 196275 1 0 $X=294675 $Y=177525
X316 19 40 GNDA GNDA ICV_9 $T=302425 201775 0 0 $X=294675 $Y=196025
X317 41 45 24 49 ICV_9 $T=338525 201775 0 0 $X=330775 $Y=196025
X318 45 25 49 28 ICV_9 $T=356575 196275 1 0 $X=348825 $Y=177525
X319 25 52 28 57 ICV_9 $T=374625 201775 0 0 $X=366875 $Y=196025
.ENDS
***************************************
.SUBCKT ICV_18 3 4 5
** N=6 EP=3 IP=10 FDC=1
M0 4 5 3 3 pmos4 L=3e-05 W=1e-05 AD=8.5e-12 AS=8.5e-12 PD=1.17e-05 PS=1.17e-05 NRD=0.0425 NRS=0.0425 $X=11250 $Y=850 $D=41
.ENDS
***************************************
.SUBCKT ICV_20 3 4 5 6 7
** N=8 EP=5 IP=12 FDC=3
M0 5 7 3 3 pmos4 L=3e-05 W=1e-05 AD=8.5e-12 AS=8.5e-12 PD=1.17e-05 PS=1.17e-05 NRD=0.0425 NRS=0.0425 $X=22500 $Y=850 $D=41
X1 3 4 7 ICV_18 $T=0 0 0 0 $X=-1200 $Y=-1200
X2 3 6 7 ICV_18 $T=22500 0 0 0 $X=21300 $Y=-1200
.ENDS
***************************************
.SUBCKT pmos4_CDNS_7807366010323
** N=5 EP=0 IP=0 FDC=0
.ENDS
***************************************
.SUBCKT ICV_23
** N=7 EP=0 IP=10 FDC=0
.ENDS
***************************************
.SUBCKT nmos4_CDNS_7807366010322
** N=4 EP=0 IP=0 FDC=0
.ENDS
***************************************
.SUBCKT ICV_21
** N=7 EP=0 IP=8 FDC=0
.ENDS
***************************************
.SUBCKT ICV_22 3 4 5 9 10 12
** N=12 EP=6 IP=14 FDC=2
M0 4 9 3 12 nmos4 L=1e-06 W=2.85e-05 AD=2.4225e-11 AS=2.4225e-11 PD=3.02e-05 PS=3.02e-05 NRD=0.0149123 NRS=0.0149123 $X=0 $Y=4150 $D=37
M1 5 10 3 12 nmos4 L=1e-06 W=2.85e-05 AD=2.4225e-11 AS=2.4225e-11 PD=3.02e-05 PS=3.02e-05 NRD=0.0149123 NRS=0.0149123 $X=0 $Y=7450 $D=37
.ENDS
***************************************
.SUBCKT cvar_CDNS_7807366010321 1 2 3
** N=3 EP=3 IP=0 FDC=2
M0 2 1 2 3 cvar w=0.00099 l=6.5e-07 cols=10 rows=15 $X=0 $Y=0 $D=62
D1 3 2 p_nwd AREA=2171.6 PJ=279.6 $X=-300 $Y=-300 $D=87
.ENDS
***************************************
.SUBCKT ICV_19 3 4 5 7
** N=7 EP=4 IP=10 FDC=1
M0 4 5 3 7 pmos4 L=2e-06 W=5e-06 AD=4.25e-12 AS=4.25e-12 PD=6.7e-06 PS=6.7e-06 NRD=0.085 NRS=0.085 $X=6250 $Y=850 $D=41
.ENDS
***************************************
.SUBCKT fbias_cur_ref2_layout VDDA GNDA OUT1 OUT2 OUT3 OUT4 OUT5 OUT6 OUT7 OUT8 OUT9 OUT10 OUT11 BIAS VRES VBG
** N=34 EP=16 IP=303 FDC=109
R0 18 21 L=3.025e-05 W=8e-07 $[rpolyh] $X=75450 $Y=124575 $D=18
D1 GNDA VDDA p_nwd AREA=3702.2 PJ=258.6 $X=8300 $Y=138325 $D=87
D2 GNDA VDDA p_nwd AREA=9463.68 PJ=531.2 $X=16950 $Y=216800 $D=87
D3 GNDA VDDA p_nwd AREA=169.219 PJ=53.25 $X=8775 $Y=187975 $D=87
D4 GNDA GNDA p_nwd AREA=352.17 PJ=78.9 $X=70700 $Y=117875 $D=87
D5 GNDA VDDA p_nwd AREA=86.1 PJ=37.4 $X=98700 $Y=165375 $D=87
D6 GNDA VDDA p_nwd AREA=943.28 PJ=202.2 $X=113250 $Y=164225 $D=87
M7 BIAS BIAS BIAS GNDA nmos4 L=1e-05 W=5e-06 AD=4.25e-12 AS=4.25e-12 PD=6.7e-06 PS=6.7e-06 NRD=0.085 NRS=0.085 $X=19950 $Y=117675 $D=38
M8 GNDA GNDA GNDA GNDA nmos4 L=1e-06 W=2.85e-05 AD=2.4225e-11 AS=2.4225e-11 PD=3.02e-05 PS=3.02e-05 NRD=0.0149123 NRS=0.0149123 $X=29700 $Y=29125 $D=38
M9 GNDA GNDA GNDA GNDA nmos4 L=1e-06 W=2.85e-05 AD=2.4225e-11 AS=2.4225e-11 PD=3.02e-05 PS=3.02e-05 NRD=0.0149123 NRS=0.0149123 $X=29700 $Y=65275 $D=38
M10 BIAS BIAS BIAS GNDA nmos4 L=1e-05 W=5e-06 AD=4.25e-12 AS=4.25e-12 PD=6.7e-06 PS=6.7e-06 NRD=0.085 NRS=0.085 $X=57450 $Y=117675 $D=38
M11 GNDA GNDA GNDA GNDA nmos4 L=1e-06 W=2.85e-05 AD=2.4225e-11 AS=2.4225e-11 PD=3.02e-05 PS=3.02e-05 NRD=0.0149123 NRS=0.0149123 $X=79200 $Y=29125 $D=38
M12 GNDA GNDA GNDA GNDA nmos4 L=1e-06 W=2.85e-05 AD=2.4225e-11 AS=2.4225e-11 PD=3.02e-05 PS=3.02e-05 NRD=0.0149123 NRS=0.0149123 $X=79200 $Y=65275 $D=38
M13 GNDA BIAS 20 GNDA nmos4 L=1e-05 W=5e-06 AD=4.25e-12 AS=4.25e-12 PD=6.7e-06 PS=6.7e-06 NRD=0.085 NRS=0.085 $X=26200 $Y=117675 $D=37
M14 GNDA BIAS BIAS GNDA nmos4 L=1e-05 W=5e-06 AD=4.25e-12 AS=4.25e-12 PD=6.7e-06 PS=6.7e-06 NRD=0.085 NRS=0.085 $X=32450 $Y=117675 $D=37
M15 GNDA BIAS 17 GNDA nmos4 L=1e-05 W=5e-06 AD=4.25e-12 AS=4.25e-12 PD=6.7e-06 PS=6.7e-06 NRD=0.085 NRS=0.085 $X=38700 $Y=117675 $D=37
M16 18 VBG 20 GNDA nmos4 L=1e-06 W=2.85e-05 AD=2.4225e-11 AS=2.4225e-11 PD=3.02e-05 PS=3.02e-05 NRD=0.0149123 NRS=0.0149123 $X=39600 $Y=29125 $D=37
M17 19 VRES 20 GNDA nmos4 L=1e-06 W=2.85e-05 AD=2.4225e-11 AS=2.4225e-11 PD=3.02e-05 PS=3.02e-05 NRD=0.0149123 NRS=0.0149123 $X=39600 $Y=65275 $D=37
M18 19 VRES 20 GNDA nmos4 L=1e-06 W=2.85e-05 AD=2.4225e-11 AS=2.4225e-11 PD=3.02e-05 PS=3.02e-05 NRD=0.0149123 NRS=0.0149123 $X=42900 $Y=29125 $D=37
M19 18 VBG 20 GNDA nmos4 L=1e-06 W=2.85e-05 AD=2.4225e-11 AS=2.4225e-11 PD=3.02e-05 PS=3.02e-05 NRD=0.0149123 NRS=0.0149123 $X=42900 $Y=65275 $D=37
M20 GNDA BIAS 20 GNDA nmos4 L=1e-05 W=5e-06 AD=4.25e-12 AS=4.25e-12 PD=6.7e-06 PS=6.7e-06 NRD=0.085 NRS=0.085 $X=44950 $Y=117675 $D=37
M21 GNDA BIAS BIAS GNDA nmos4 L=1e-05 W=5e-06 AD=4.25e-12 AS=4.25e-12 PD=6.7e-06 PS=6.7e-06 NRD=0.085 NRS=0.085 $X=51200 $Y=117675 $D=37
M22 18 VBG 20 GNDA nmos4 L=1e-06 W=2.85e-05 AD=2.4225e-11 AS=2.4225e-11 PD=3.02e-05 PS=3.02e-05 NRD=0.0149123 NRS=0.0149123 $X=52800 $Y=29125 $D=37
M23 19 VRES 20 GNDA nmos4 L=1e-06 W=2.85e-05 AD=2.4225e-11 AS=2.4225e-11 PD=3.02e-05 PS=3.02e-05 NRD=0.0149123 NRS=0.0149123 $X=52800 $Y=65275 $D=37
M24 19 VRES 20 GNDA nmos4 L=1e-06 W=2.85e-05 AD=2.4225e-11 AS=2.4225e-11 PD=3.02e-05 PS=3.02e-05 NRD=0.0149123 NRS=0.0149123 $X=56100 $Y=29125 $D=37
M25 18 VBG 20 GNDA nmos4 L=1e-06 W=2.85e-05 AD=2.4225e-11 AS=2.4225e-11 PD=3.02e-05 PS=3.02e-05 NRD=0.0149123 NRS=0.0149123 $X=56100 $Y=65275 $D=37
M26 18 VBG 20 GNDA nmos4 L=1e-06 W=2.85e-05 AD=2.4225e-11 AS=2.4225e-11 PD=3.02e-05 PS=3.02e-05 NRD=0.0149123 NRS=0.0149123 $X=66000 $Y=29125 $D=37
M27 19 VRES 20 GNDA nmos4 L=1e-06 W=2.85e-05 AD=2.4225e-11 AS=2.4225e-11 PD=3.02e-05 PS=3.02e-05 NRD=0.0149123 NRS=0.0149123 $X=66000 $Y=65275 $D=37
M28 19 VRES 20 GNDA nmos4 L=1e-06 W=2.85e-05 AD=2.4225e-11 AS=2.4225e-11 PD=3.02e-05 PS=3.02e-05 NRD=0.0149123 NRS=0.0149123 $X=69300 $Y=29125 $D=37
M29 18 VBG 20 GNDA nmos4 L=1e-06 W=2.85e-05 AD=2.4225e-11 AS=2.4225e-11 PD=3.02e-05 PS=3.02e-05 NRD=0.0149123 NRS=0.0149123 $X=69300 $Y=65275 $D=37
M30 18 18 18 VDDA pmos4 L=3e-05 W=1e-05 AD=8.5e-12 AS=8.5e-12 PD=1.17e-05 PS=1.17e-05 NRD=0.0425 NRS=0.0425 $X=22300 $Y=223000 $D=42
M31 19 19 19 VDDA pmos4 L=5e-06 W=8.35e-06 AD=7.0975e-12 AS=7.0975e-12 PD=1.005e-05 PS=1.005e-05 NRD=0.0508982 NRS=0.0508982 $X=23500 $Y=149675 $D=42
M32 19 19 19 VDDA pmos4 L=5e-06 W=8.35e-06 AD=7.0975e-12 AS=7.0975e-12 PD=1.005e-05 PS=1.005e-05 NRD=0.0508982 NRS=0.0508982 $X=23500 $Y=161425 $D=42
M33 19 19 19 VDDA pmos4 L=5e-06 W=8.35e-06 AD=7.0975e-12 AS=7.0975e-12 PD=1.005e-05 PS=1.005e-05 NRD=0.0508982 NRS=0.0508982 $X=74600 $Y=149675 $D=42
M34 19 19 19 VDDA pmos4 L=5e-06 W=8.35e-06 AD=7.0975e-12 AS=7.0975e-12 PD=1.005e-05 PS=1.005e-05 NRD=0.0508982 NRS=0.0508982 $X=74600 $Y=161425 $D=42
M35 17 17 17 VDDA pmos4 L=2e-06 W=5e-06 AD=4.25e-12 AS=4.25e-12 PD=6.7e-06 PS=6.7e-06 NRD=0.085 NRS=0.085 $X=118600 $Y=168425 $D=42
M36 17 17 17 VDDA pmos4 L=2e-06 W=5e-06 AD=4.25e-12 AS=4.25e-12 PD=6.7e-06 PS=6.7e-06 NRD=0.085 NRS=0.085 $X=193600 $Y=168425 $D=42
M37 18 18 18 VDDA pmos4 L=3e-05 W=1e-05 AD=8.5e-12 AS=8.5e-12 PD=1.17e-05 PS=1.17e-05 NRD=0.0425 NRS=0.0425 $X=224800 $Y=223000 $D=42
M38 34 17 17 VDDA pmos4 L=2e-06 W=5e-06 AD=4.25e-12 AS=4.25e-12 PD=6.7e-06 PS=6.7e-06 NRD=0.085 NRS=0.085 $X=11525 $Y=191575 $D=41
M39 18 19 VDDA VDDA pmos4 L=5e-06 W=8.35e-06 AD=7.0975e-12 AS=7.0975e-12 PD=1.005e-05 PS=1.005e-05 NRD=0.0508982 NRS=0.0508982 $X=30800 $Y=149675 $D=41
M40 19 19 VDDA VDDA pmos4 L=5e-06 W=8.35e-06 AD=7.0975e-12 AS=7.0975e-12 PD=1.005e-05 PS=1.005e-05 NRD=0.0508982 NRS=0.0508982 $X=30800 $Y=161425 $D=41
M41 19 19 VDDA VDDA pmos4 L=5e-06 W=8.35e-06 AD=7.0975e-12 AS=7.0975e-12 PD=1.005e-05 PS=1.005e-05 NRD=0.0508982 NRS=0.0508982 $X=38100 $Y=149675 $D=41
M42 18 19 VDDA VDDA pmos4 L=5e-06 W=8.35e-06 AD=7.0975e-12 AS=7.0975e-12 PD=1.005e-05 PS=1.005e-05 NRD=0.0508982 NRS=0.0508982 $X=38100 $Y=161425 $D=41
M43 18 19 VDDA VDDA pmos4 L=5e-06 W=8.35e-06 AD=7.0975e-12 AS=7.0975e-12 PD=1.005e-05 PS=1.005e-05 NRD=0.0508982 NRS=0.0508982 $X=45400 $Y=149675 $D=41
M44 19 19 VDDA VDDA pmos4 L=5e-06 W=8.35e-06 AD=7.0975e-12 AS=7.0975e-12 PD=1.005e-05 PS=1.005e-05 NRD=0.0508982 NRS=0.0508982 $X=45400 $Y=161425 $D=41
M45 19 19 VDDA VDDA pmos4 L=5e-06 W=8.35e-06 AD=7.0975e-12 AS=7.0975e-12 PD=1.005e-05 PS=1.005e-05 NRD=0.0508982 NRS=0.0508982 $X=52700 $Y=149675 $D=41
M46 18 19 VDDA VDDA pmos4 L=5e-06 W=8.35e-06 AD=7.0975e-12 AS=7.0975e-12 PD=1.005e-05 PS=1.005e-05 NRD=0.0508982 NRS=0.0508982 $X=52700 $Y=161425 $D=41
M47 18 19 VDDA VDDA pmos4 L=5e-06 W=8.35e-06 AD=7.0975e-12 AS=7.0975e-12 PD=1.005e-05 PS=1.005e-05 NRD=0.0508982 NRS=0.0508982 $X=60000 $Y=149675 $D=41
M48 19 19 VDDA VDDA pmos4 L=5e-06 W=8.35e-06 AD=7.0975e-12 AS=7.0975e-12 PD=1.005e-05 PS=1.005e-05 NRD=0.0508982 NRS=0.0508982 $X=60000 $Y=161425 $D=41
M49 19 19 VDDA VDDA pmos4 L=5e-06 W=8.35e-06 AD=7.0975e-12 AS=7.0975e-12 PD=1.005e-05 PS=1.005e-05 NRD=0.0508982 NRS=0.0508982 $X=67300 $Y=149675 $D=41
M50 18 19 VDDA VDDA pmos4 L=5e-06 W=8.35e-06 AD=7.0975e-12 AS=7.0975e-12 PD=1.005e-05 PS=1.005e-05 NRD=0.0508982 NRS=0.0508982 $X=67300 $Y=161425 $D=41
M51 VDDA 18 22 VDDA pmos4 L=3e-05 W=1e-05 AD=8.5e-12 AS=8.5e-12 PD=1.17e-05 PS=1.17e-05 NRD=0.0425 NRS=0.0425 $X=67300 $Y=223000 $D=41
M52 VDDA 18 28 VDDA pmos4 L=3e-05 W=1e-05 AD=8.5e-12 AS=8.5e-12 PD=1.17e-05 PS=1.17e-05 NRD=0.0425 NRS=0.0425 $X=112300 $Y=223000 $D=41
M53 25 17 OUT2 VDDA pmos4 L=2e-06 W=5e-06 AD=4.25e-12 AS=4.25e-12 PD=6.7e-06 PS=6.7e-06 NRD=0.085 NRS=0.085 $X=131100 $Y=168425 $D=41
M54 27 17 OUT4 VDDA pmos4 L=2e-06 W=5e-06 AD=4.25e-12 AS=4.25e-12 PD=6.7e-06 PS=6.7e-06 NRD=0.085 NRS=0.085 $X=143600 $Y=168425 $D=41
M55 29 17 OUT6 VDDA pmos4 L=2e-06 W=5e-06 AD=4.25e-12 AS=4.25e-12 PD=6.7e-06 PS=6.7e-06 NRD=0.085 NRS=0.085 $X=156100 $Y=168425 $D=41
M56 VDDA 18 30 VDDA pmos4 L=3e-05 W=1e-05 AD=8.5e-12 AS=8.5e-12 PD=1.17e-05 PS=1.17e-05 NRD=0.0425 NRS=0.0425 $X=157300 $Y=223000 $D=41
M57 30 17 OUT8 VDDA pmos4 L=2e-06 W=5e-06 AD=4.25e-12 AS=4.25e-12 PD=6.7e-06 PS=6.7e-06 NRD=0.085 NRS=0.085 $X=168600 $Y=168425 $D=41
M58 32 17 OUT10 VDDA pmos4 L=2e-06 W=5e-06 AD=4.25e-12 AS=4.25e-12 PD=6.7e-06 PS=6.7e-06 NRD=0.085 NRS=0.085 $X=181100 $Y=168425 $D=41
M59 VDDA 18 22 VDDA pmos4 L=3e-05 W=1e-05 AD=8.5e-12 AS=8.5e-12 PD=1.17e-05 PS=1.17e-05 NRD=0.0425 NRS=0.0425 $X=202300 $Y=223000 $D=41
X60 VDDA 34 34 VDDA pmos4_CDNS_7807366010317 $T=11525 199475 1 0 $X=10325 $Y=195575
X61 22 VRES 17 VDDA pmos4_CDNS_7807366010317 $T=101450 170825 1 0 $X=100250 $Y=166925
X72 VDDA 33 18 ICV_18 $T=202300 253850 1 0 $X=201100 $Y=220950
X73 VDDA 22 24 25 18 ICV_20 $T=22300 253850 1 0 $X=21100 $Y=220950
X74 VDDA 26 27 22 18 ICV_20 $T=67300 253850 1 0 $X=66100 $Y=220950
X75 VDDA 29 22 23 18 ICV_20 $T=112300 253850 1 0 $X=111100 $Y=220950
X76 VDDA 22 31 32 18 ICV_20 $T=157300 253850 1 0 $X=156100 $Y=220950
X85 20 18 19 VBG VRES GNDA ICV_22 $T=28850 57625 0 270 $X=28600 $Y=28725
X86 20 19 18 VRES VBG GNDA ICV_22 $T=28850 93775 0 270 $X=28600 $Y=64875
X87 20 18 19 VBG VRES GNDA ICV_22 $T=42050 57625 0 270 $X=41800 $Y=28725
X88 20 19 18 VRES VBG GNDA ICV_22 $T=42050 93775 0 270 $X=41800 $Y=64875
X89 20 18 19 VBG VRES GNDA ICV_22 $T=55250 57625 0 270 $X=55000 $Y=28725
X90 20 19 18 VRES VBG GNDA ICV_22 $T=55250 93775 0 270 $X=55000 $Y=64875
X91 20 18 19 VBG VRES GNDA ICV_22 $T=68450 57625 0 270 $X=68200 $Y=28725
X92 20 19 18 VRES VBG GNDA ICV_22 $T=68450 93775 0 270 $X=68200 $Y=64875
X93 21 VRES GNDA cvar_CDNS_7807366010321 $T=120200 14800 1 180 $X=100375 $Y=13250
X94 21 VRES GNDA cvar_CDNS_7807366010321 $T=143350 14800 1 180 $X=123525 $Y=13250
X95 21 VRES GNDA cvar_CDNS_7807366010321 $T=166500 14800 1 180 $X=146675 $Y=13250
X96 21 VRES GNDA cvar_CDNS_7807366010321 $T=189650 14800 1 180 $X=169825 $Y=13250
X97 21 VRES GNDA cvar_CDNS_7807366010321 $T=212800 14800 1 180 $X=192975 $Y=13250
X98 21 VRES GNDA cvar_CDNS_7807366010321 $T=235950 14800 1 180 $X=216125 $Y=13250
X99 24 OUT1 17 VDDA ICV_19 $T=118600 171275 1 0 $X=117400 $Y=166375
X100 26 OUT3 17 VDDA ICV_19 $T=131100 171275 1 0 $X=129900 $Y=166375
X101 28 OUT5 17 VDDA ICV_19 $T=143600 171275 1 0 $X=142400 $Y=166375
X102 23 OUT7 17 VDDA ICV_19 $T=156100 171275 1 0 $X=154900 $Y=166375
X103 31 OUT9 17 VDDA ICV_19 $T=168600 171275 1 0 $X=167400 $Y=166375
X104 33 OUT11 17 VDDA ICV_19 $T=181100 171275 1 0 $X=179900 $Y=166375
.ENDS
***************************************
.SUBCKT ICV_26
** N=7 EP=0 IP=10 FDC=0
.ENDS
***************************************
.SUBCKT ICV_27 3 4 5 8
** N=9 EP=4 IP=14 FDC=2
M0 4 8 3 3 pmos4 L=1e-05 W=5e-06 AD=4.25e-12 AS=4.25e-12 PD=6.7e-06 PS=6.7e-06 NRD=0.085 NRS=0.085 $X=6300 $Y=850 $D=41
M1 5 8 3 3 pmos4 L=1e-05 W=5e-06 AD=4.25e-12 AS=4.25e-12 PD=6.7e-06 PS=6.7e-06 NRD=0.085 NRS=0.085 $X=12600 $Y=850 $D=41
.ENDS
***************************************
.SUBCKT ICV_29 1 2 3 4
** N=5 EP=4 IP=18 FDC=8
M0 1 1 1 2 pmos4 L=1e-05 W=5e-06 AD=4.25e-12 AS=4.25e-12 PD=6.7e-06 PS=6.7e-06 NRD=0.085 NRS=0.085 $X=0 $Y=850 $D=42
M1 3 1 2 2 pmos4 L=1e-05 W=5e-06 AD=4.25e-12 AS=4.25e-12 PD=6.7e-06 PS=6.7e-06 NRD=0.085 NRS=0.085 $X=18900 $Y=850 $D=41
M2 4 1 2 2 pmos4 L=1e-05 W=5e-06 AD=4.25e-12 AS=4.25e-12 PD=6.7e-06 PS=6.7e-06 NRD=0.085 NRS=0.085 $X=25200 $Y=850 $D=41
M3 3 1 2 2 pmos4 L=1e-05 W=5e-06 AD=4.25e-12 AS=4.25e-12 PD=6.7e-06 PS=6.7e-06 NRD=0.085 NRS=0.085 $X=44100 $Y=850 $D=41
X4 2 3 4 1 ICV_27 $T=0 0 0 0 $X=-1200 $Y=-1200
X5 2 3 4 1 ICV_27 $T=25200 0 0 0 $X=24000 $Y=-1200
.ENDS
***************************************
.SUBCKT nmos4_CDNS_7807366010326
** N=4 EP=0 IP=0 FDC=0
.ENDS
***************************************
.SUBCKT ICV_24
** N=7 EP=0 IP=8 FDC=0
.ENDS
***************************************
.SUBCKT ICV_25 1 2 3 6 7 9
** N=9 EP=6 IP=14 FDC=3
M0 2 6 1 9 nmos4 L=5e-06 W=3.3e-05 AD=2.805e-11 AS=2.805e-11 PD=3.47e-05 PS=3.47e-05 NRD=0.0128788 NRS=0.0128788 $X=0 $Y=-21050 $D=37
M1 3 7 1 9 nmos4 L=5e-06 W=3.3e-05 AD=2.805e-11 AS=2.805e-11 PD=3.47e-05 PS=3.47e-05 NRD=0.0128788 NRS=0.0128788 $X=0 $Y=-13750 $D=37
M2 2 6 1 9 nmos4 L=5e-06 W=3.3e-05 AD=2.805e-11 AS=2.805e-11 PD=3.47e-05 PS=3.47e-05 NRD=0.0128788 NRS=0.0128788 $X=0 $Y=-6450 $D=37
.ENDS
***************************************
.SUBCKT ICV_28 1 2 3 4 5 6
** N=6 EP=6 IP=18 FDC=8
M0 4 4 4 4 nmos4 L=5e-06 W=3.3e-05 AD=2.805e-11 AS=2.805e-11 PD=3.47e-05 PS=3.47e-05 NRD=0.0128788 NRS=0.0128788 $X=0 $Y=850 $D=38
M1 3 6 1 4 nmos4 L=5e-06 W=3.3e-05 AD=2.805e-11 AS=2.805e-11 PD=3.47e-05 PS=3.47e-05 NRD=0.0128788 NRS=0.0128788 $X=0 $Y=-28350 $D=37
X2 1 2 3 5 6 4 ICV_25 $T=0 -29200 0 0 $X=-400 $Y=-51350
X3 1 2 3 5 6 4 ICV_25 $T=0 0 0 0 $X=-400 $Y=-22150
.ENDS
***************************************
.SUBCKT PD_C_CDNS_78073660103209
** N=1 EP=0 IP=0 FDC=0
.ENDS
***************************************
.SUBCKT PD_C_CDNS_78073660103211
** N=1 EP=0 IP=0 FDC=0
.ENDS
***************************************
.SUBCKT PD_C_CDNS_78073660103210
** N=1 EP=0 IP=0 FDC=0
.ENDS
***************************************
.SUBCKT rpolyhc_CDNS_7807366010324 1 2
** N=3 EP=2 IP=0 FDC=1
R0 1 2 L=2.5e-05 W=8e-07 $[rpolyh] $X=-800 $Y=1550 $D=18
.ENDS
***************************************
.SUBCKT fbias_vol_ref1_layout BIAS VDDA GNDA VBG V1600 V1500 V1000
** N=32 EP=7 IP=239 FDC=108
R0 8 13 L=8.995e-05 W=2e-06 $[rpolyh] $X=342050 $Y=248400 $D=18
D1 GNDA VDDA p_nwd AREA=6035.8 PJ=323.2 $X=226125 $Y=216950 $D=87
D2 GNDA GNDA p_nwd AREA=3481.19 PJ=240 $X=275800 $Y=154500 $D=87
D3 GNDA VDDA p_nwd AREA=508.68 PJ=96.2 $X=333800 $Y=206850 $D=87
D4 GNDA GNDA p_nwd AREA=638.775 PJ=101.1 $X=337400 $Y=244100 $D=87
M5 GNDA GNDA GNDA GNDA nmos4 L=5e-06 W=3.3e-05 AD=2.805e-11 AS=2.805e-11 PD=3.47e-05 PS=3.47e-05 NRD=0.0128788 NRS=0.0128788 $X=339750 $Y=60200 $D=38
M6 GNDA GNDA GNDA GNDA nmos4 L=5e-06 W=3.3e-05 AD=2.805e-11 AS=2.805e-11 PD=3.47e-05 PS=3.47e-05 NRD=0.0128788 NRS=0.0128788 $X=339750 $Y=99500 $D=38
M7 GNDA BIAS 10 GNDA nmos4 L=1e-05 W=5e-06 AD=4.25e-12 AS=4.25e-12 PD=6.7e-06 PS=6.7e-06 NRD=0.085 NRS=0.085 $X=239550 $Y=163000 $D=37
M8 GNDA BIAS BIAS GNDA nmos4 L=1e-05 W=5e-06 AD=4.25e-12 AS=4.25e-12 PD=6.7e-06 PS=6.7e-06 NRD=0.085 NRS=0.085 $X=239550 $Y=170700 $D=37
M9 GNDA BIAS BIAS GNDA nmos4 L=1e-05 W=5e-06 AD=4.25e-12 AS=4.25e-12 PD=6.7e-06 PS=6.7e-06 NRD=0.085 NRS=0.085 $X=251850 $Y=163000 $D=37
M10 GNDA BIAS 10 GNDA nmos4 L=1e-05 W=5e-06 AD=4.25e-12 AS=4.25e-12 PD=6.7e-06 PS=6.7e-06 NRD=0.085 NRS=0.085 $X=251850 $Y=170700 $D=37
M11 10 VBG 8 GNDA nmos4 L=5e-06 W=3.3e-05 AD=2.805e-11 AS=2.805e-11 PD=3.47e-05 PS=3.47e-05 NRD=0.0128788 NRS=0.0128788 $X=303250 $Y=60200 $D=37
M12 10 11 9 GNDA nmos4 L=5e-06 W=3.3e-05 AD=2.805e-11 AS=2.805e-11 PD=3.47e-05 PS=3.47e-05 NRD=0.0128788 NRS=0.0128788 $X=303250 $Y=99500 $D=37
M13 10 VBG 8 GNDA nmos4 L=5e-06 W=3.3e-05 AD=2.805e-11 AS=2.805e-11 PD=3.47e-05 PS=3.47e-05 NRD=0.0128788 NRS=0.0128788 $X=332450 $Y=60200 $D=37
M14 10 11 9 GNDA nmos4 L=5e-06 W=3.3e-05 AD=2.805e-11 AS=2.805e-11 PD=3.47e-05 PS=3.47e-05 NRD=0.0128788 NRS=0.0128788 $X=332450 $Y=99500 $D=37
M15 9 9 9 VDDA pmos4 L=1e-05 W=5e-06 AD=4.25e-12 AS=4.25e-12 PD=6.7e-06 PS=6.7e-06 NRD=0.085 NRS=0.085 $X=309775 $Y=232150 $D=42
M16 9 9 9 VDDA pmos4 L=1e-05 W=5e-06 AD=4.25e-12 AS=4.25e-12 PD=6.7e-06 PS=6.7e-06 NRD=0.085 NRS=0.085 $X=309775 $Y=250350 $D=42
M17 VDDA 9 8 VDDA pmos4 L=1e-05 W=5e-06 AD=4.25e-12 AS=4.25e-12 PD=6.7e-06 PS=6.7e-06 NRD=0.085 NRS=0.085 $X=290875 $Y=232150 $D=41
M18 9 9 VDDA VDDA pmos4 L=1e-05 W=5e-06 AD=4.25e-12 AS=4.25e-12 PD=6.7e-06 PS=6.7e-06 NRD=0.085 NRS=0.085 $X=290875 $Y=250350 $D=41
M19 VDDA 8 14 VDDA pmos4 L=2e-05 W=1e-05 AD=8.5e-12 AS=8.5e-12 PD=1.17e-05 PS=1.17e-05 NRD=0.0425 NRS=0.0425 $X=337150 $Y=213050 $D=41
X30 13 14 GNDA cvar_CDNS_7807366010321 $T=372725 42075 0 270 $X=371175 $Y=22250
X31 13 14 GNDA cvar_CDNS_7807366010321 $T=372725 65225 0 270 $X=371175 $Y=45400
X32 13 14 GNDA cvar_CDNS_7807366010321 $T=372725 88375 0 270 $X=371175 $Y=68550
X33 13 14 GNDA cvar_CDNS_7807366010321 $T=372725 111525 0 270 $X=371175 $Y=91700
X34 13 14 GNDA cvar_CDNS_7807366010321 $T=372725 134675 0 270 $X=371175 $Y=114850
X35 13 14 GNDA cvar_CDNS_7807366010321 $T=372725 157825 0 270 $X=371175 $Y=138000
X36 13 14 GNDA cvar_CDNS_7807366010321 $T=372725 180975 0 270 $X=371175 $Y=161150
X37 13 14 GNDA cvar_CDNS_7807366010321 $T=372725 204125 0 270 $X=371175 $Y=184300
X38 13 14 GNDA cvar_CDNS_7807366010321 $T=372725 227275 0 270 $X=371175 $Y=207450
X39 13 14 GNDA cvar_CDNS_7807366010321 $T=372725 250425 0 270 $X=371175 $Y=230600
X40 13 14 GNDA cvar_CDNS_7807366010321 $T=372725 273575 0 270 $X=371175 $Y=253750
X41 VDDA 9 8 9 ICV_27 $T=290875 243000 1 0 $X=289675 $Y=230100
X42 VDDA 8 9 9 ICV_27 $T=290875 249500 0 0 $X=289675 $Y=248300
X43 9 VDDA 9 8 ICV_29 $T=240475 243000 1 0 $X=239275 $Y=230100
X44 9 VDDA 8 9 ICV_29 $T=240475 249500 0 0 $X=239275 $Y=248300
X47 10 9 8 11 VBG GNDA ICV_25 $T=309100 60200 0 90 $X=302150 $Y=59800
X48 10 8 9 VBG 11 GNDA ICV_25 $T=309100 99500 0 90 $X=302150 $Y=99100
X49 10 9 8 GNDA 11 VBG ICV_28 $T=250700 60200 0 90 $X=243750 $Y=59800
X50 10 8 9 GNDA VBG 11 ICV_28 $T=250700 99500 0 90 $X=243750 $Y=99100
X85 GNDA 16 rpolyhc_CDNS_7807366010324 $T=289000 162050 0 90 $X=277350 $Y=156050
X86 16 17 rpolyhc_CDNS_7807366010324 $T=282000 172050 1 90 $X=277350 $Y=166050
X87 17 15 rpolyhc_CDNS_7807366010324 $T=289000 182050 0 90 $X=277350 $Y=176050
X88 15 12 rpolyhc_CDNS_7807366010324 $T=282000 196050 0 270 $X=277350 $Y=186050
X89 18 24 rpolyhc_CDNS_7807366010324 $T=292300 166050 0 270 $X=287650 $Y=156050
X90 20 18 rpolyhc_CDNS_7807366010324 $T=299300 176050 1 270 $X=287650 $Y=166050
X91 19 20 rpolyhc_CDNS_7807366010324 $T=292300 186050 0 270 $X=287650 $Y=176050
X92 V1600 19 rpolyhc_CDNS_7807366010324 $T=299300 196050 1 270 $X=287650 $Y=186050
X93 11 21 rpolyhc_CDNS_7807366010324 $T=302600 162050 1 90 $X=297950 $Y=156050
X94 22 11 rpolyhc_CDNS_7807366010324 $T=309600 176050 1 270 $X=297950 $Y=166050
X95 V1500 V1600 rpolyhc_CDNS_7807366010324 $T=309600 182050 0 90 $X=297950 $Y=176050
X96 12 30 rpolyhc_CDNS_7807366010324 $T=302600 192050 1 90 $X=297950 $Y=186050
X97 28 V1000 rpolyhc_CDNS_7807366010324 $T=312900 162050 1 90 $X=308250 $Y=156050
X98 21 23 rpolyhc_CDNS_7807366010324 $T=312900 172050 1 90 $X=308250 $Y=166050
X99 V1000 22 rpolyhc_CDNS_7807366010324 $T=319900 186050 1 270 $X=308250 $Y=176050
X100 23 V1500 rpolyhc_CDNS_7807366010324 $T=319900 192050 0 90 $X=308250 $Y=186050
X101 24 26 rpolyhc_CDNS_7807366010324 $T=323200 162050 1 90 $X=318550 $Y=156050
X102 26 25 rpolyhc_CDNS_7807366010324 $T=330200 172050 0 90 $X=318550 $Y=166050
X103 25 27 rpolyhc_CDNS_7807366010324 $T=323200 182050 1 90 $X=318550 $Y=176050
X104 27 14 rpolyhc_CDNS_7807366010324 $T=330200 192050 0 90 $X=318550 $Y=186050
X105 31 28 rpolyhc_CDNS_7807366010324 $T=340500 166050 1 270 $X=328850 $Y=156050
X106 29 31 rpolyhc_CDNS_7807366010324 $T=333500 176050 0 270 $X=328850 $Y=166050
X107 32 29 rpolyhc_CDNS_7807366010324 $T=340500 186050 1 270 $X=328850 $Y=176050
X108 30 32 rpolyhc_CDNS_7807366010324 $T=333500 196050 0 270 $X=328850 $Y=186050
.ENDS
***************************************
.SUBCKT fbias_bias2_f 1 2 POR_L 4 VDDA VRES OUT1 OUT2 OUT3 OUT4 OUT5 OUT6 OUT7 v1000 v1500 GNDA
** N=23 EP=16 IP=61 FDC=601
X0 VDDA GNDA V500_20 $T=212550 23500 1 0 $X=212350 $Y=-600
X1 VDDA GNDA V500_20 $T=228100 330250 1 0 $X=227900 $Y=306150
X2 VDDA GNDA V500_20 $T=863100 23500 1 0 $X=862900 $Y=-600
X3 VDDA GNDA V500_20 $T=863400 330250 1 0 $X=863200 $Y=306150
X4 VDDA GNDA V200_20 $T=23825 89875 0 90 $X=-225 $Y=89925
X5 VDDA GNDA V200_20 $T=184550 84150 1 0 $X=184600 $Y=60100
X6 VDDA GNDA V200_20 $T=184825 53650 1 0 $X=184875 $Y=29600
X7 VDDA GNDA V200_20 $T=845575 69175 0 90 $X=821525 $Y=69225
X8 VDDA GNDA V200_20 $T=1401725 69575 0 90 $X=1377675 $Y=69625
X9 GNDA 17 VDDA 4 POR_L fbias_por2_fc $T=36050 91150 0 0 $X=35800 $Y=95348
X10 2 17 18 1 GNDA VDDA fbias_gm_c1_f2c $T=236850 94900 0 0 $X=241950 $Y=104198
X11 4 VDDA GNDA 18 fecg_bandgap3_layout $T=406250 -80300 0 0 $X=408525 $Y=32048
X12 VDDA GNDA OUT1 OUT2 OUT3 OUT4 OUT5 OUT6 OUT7 OUT8 OUT9 OUT10 OUT11 2 VRES 4 fbias_cur_ref2_layout $T=849150 29500 0 0 $X=847750 $Y=35223
X13 1 VDDA GNDA 4 v1600 v1500 v1000 fbias_vol_ref1_layout $T=876650 14550 0 0 $X=1096300 $Y=31173
.ENDS
***************************************
.SUBCKT PERI_SPACER_20_P
** N=6 EP=0 IP=0 FDC=0
.ENDS
***************************************
.SUBCKT topsy GNDDO VDDDO VDDD RESET_L CLK4K GNDDR SPI_CLK SPI_MOSI GNDD VDDDR SPI_CS GNDA VINPS VDDA VINNS VINP CMS CMFBS VINN CM
+ EXC1S CMFB EXC2S EXC1 CVGAS CBUFS EXC2 ECGS CVGA VDDAS CBUF FECG GNDAS CE TIA_IN WE V_EC VPI RE POT_OUT
+ VRESS VRES
** N=133 EP=42 IP=835 FDC=10817
D0 GNDDR VDDDR p_nwd AREA=5325.07 PJ=441 $X=262150 $Y=240400 $D=87
D1 GNDDR VDDDR p_nwd AREA=2487.45 PJ=206 $X=262150 $Y=557900 $D=87
D2 GNDDR VDDDR p_nwd AREA=2487.45 PJ=206 $X=262150 $Y=757900 $D=87
D3 GNDDR VDDDR p_nwd AREA=2487.45 PJ=206 $X=262150 $Y=957900 $D=87
D4 GNDDR VDDDR p_nwd AREA=2451.22 PJ=203 $X=262150 $Y=1157900 $D=87
D5 GNDDR VDDDR p_nwd AREA=2419.83 PJ=224.55 $X=262150 $Y=1359400 $D=87
D6 GNDDR VDDDR p_nwd AREA=2424.66 PJ=249.1 $X=262150 $Y=1559200 $D=87
D7 GNDDR VDDDR p_nwd AREA=2424.66 PJ=249.1 $X=262150 $Y=1759200 $D=87
D8 GNDDR VDDDR p_nwd AREA=2424.66 PJ=249.1 $X=262150 $Y=1959200 $D=87
D9 GNDDR VDDDR p_nwd AREA=2424.66 PJ=249.1 $X=262150 $Y=2159200 $D=87
D10 GNDDR VDDDR p_nwd AREA=2456.05 PJ=227.55 $X=262150 $Y=2359200 $D=87
D11 GNDDR VDDDR p_nwd AREA=4868.64 PJ=403.2 $X=262150 $Y=2557900 $D=87
D12 GNDDR VDDDR p_nwd AREA=4222.57 PJ=441 $X=319650 $Y=240400 $D=87
D13 GNDDR VDDDR p_nwd AREA=1972.45 PJ=206 $X=319650 $Y=557900 $D=87
D14 GNDDR VDDDR p_nwd AREA=1972.45 PJ=206 $X=319650 $Y=757900 $D=87
D15 GNDDR VDDDR p_nwd AREA=1972.45 PJ=206 $X=319650 $Y=957900 $D=87
D16 GNDDR VDDDR p_nwd AREA=1959.04 PJ=204.6 $X=319650 $Y=1157900 $D=87
D17 GNDDR VDDDR p_nwd AREA=1918.83 PJ=219.55 $X=319650 $Y=1359400 $D=87
D18 GNDDR VDDDR p_nwd AREA=1934.15 PJ=221.15 $X=319650 $Y=1559200 $D=87
D19 GNDDR VDDDR p_nwd AREA=1934.15 PJ=221.15 $X=319650 $Y=1758600 $D=87
D20 GNDDR VDDDR p_nwd AREA=1922.66 PJ=239.1 $X=319650 $Y=1959200 $D=87
D21 GNDDR VDDDR p_nwd AREA=1922.66 PJ=239.1 $X=319650 $Y=2159200 $D=87
D22 GNDDR VDDDR p_nwd AREA=1947.55 PJ=222.55 $X=319650 $Y=2359200 $D=87
D23 GNDDR VDDDR p_nwd AREA=3858.72 PJ=403 $X=319650 $Y=2557900 $D=87
D24 60 62 p_nwd AREA=34837.6 PJ=6402.77 $X=262150 $Y=129650 $D=87
D25 60 62 p_nwd AREA=4258.31 PJ=442.457 $X=319650 $Y=177300 $D=87
D26 61 63 p_nwd AREA=4258.31 PJ=442.457 $X=319650 $Y=2809400 $D=87
D27 61 63 p_nwd AREA=7945.48 PJ=652.47 $X=262150 $Y=2809400 $D=87
D28 60 62 p_nwd AREA=1972.45 PJ=206 $X=638900 $Y=169650 $D=87
D29 61 63 p_nwd AREA=1972.45 PJ=206 $X=638900 $Y=2811000 $D=87
D30 61 63 p_nwd AREA=2487.45 PJ=206 $X=638900 $Y=2863500 $D=87
D31 60 62 p_nwd AREA=1972.45 PJ=206 $X=838900 $Y=169650 $D=87
D32 61 63 p_nwd AREA=1972.45 PJ=206 $X=838900 $Y=2811000 $D=87
D33 61 63 p_nwd AREA=62879 PJ=11856.8 $X=838900 $Y=2863500 $D=87
D34 60 62 p_nwd AREA=1972.45 PJ=206 $X=1038900 $Y=169650 $D=87
D35 61 63 p_nwd AREA=1972.45 PJ=206 $X=1038900 $Y=2811000 $D=87
D36 60 62 p_nwd AREA=1972.45 PJ=206 $X=1238900 $Y=169650 $D=87
D37 61 63 p_nwd AREA=1972.45 PJ=206 $X=1238900 $Y=2811000 $D=87
D38 60 62 p_nwd AREA=1972.45 PJ=206 $X=1438900 $Y=169650 $D=87
D39 61 63 p_nwd AREA=1972.45 PJ=206 $X=1438900 $Y=2811000 $D=87
D40 60 62 p_nwd AREA=1972.45 PJ=206 $X=1638900 $Y=169650 $D=87
D41 61 63 p_nwd AREA=1972.45 PJ=206 $X=1638900 $Y=2811000 $D=87
D42 60 62 p_nwd AREA=1972.45 PJ=206 $X=1838900 $Y=169650 $D=87
D43 61 63 p_nwd AREA=1972.45 PJ=206 $X=1838900 $Y=2811000 $D=87
D44 60 62 p_nwd AREA=1972.45 PJ=206 $X=2038900 $Y=169650 $D=87
D45 61 63 p_nwd AREA=1972.45 PJ=206 $X=2038900 $Y=2811000 $D=87
D46 60 62 p_nwd AREA=1972.45 PJ=206 $X=2238900 $Y=169650 $D=87
D47 61 63 p_nwd AREA=1972.45 PJ=206 $X=2238900 $Y=2811000 $D=87
D48 60 62 p_nwd AREA=2487.45 PJ=206 $X=2438900 $Y=112150 $D=87
D49 60 62 p_nwd AREA=1972.45 PJ=206 $X=2438900 $Y=169650 $D=87
D50 61 63 p_nwd AREA=1972.45 PJ=206 $X=2438900 $Y=2811000 $D=87
D51 60 62 p_nwd AREA=14290.1 PJ=1569.37 $X=2638900 $Y=112150 $D=87
D52 60 62 p_nwd AREA=8863.89 PJ=923.457 $X=2638900 $Y=169650 $D=87
D53 61 63 p_nwd AREA=7542.54 PJ=785.457 $X=2638900 $Y=2811000 $D=87
D54 61 63 p_nwd AREA=1943.72 PJ=203 $X=2812000 $Y=609400 $D=87
D55 61 63 p_nwd AREA=1972.45 PJ=206 $X=2812000 $Y=807900 $D=87
D56 61 63 p_nwd AREA=1972.45 PJ=206 $X=2812000 $Y=1007900 $D=87
D57 61 63 p_nwd AREA=1972.45 PJ=206 $X=2812000 $Y=1207900 $D=87
D58 61 63 p_nwd AREA=1972.45 PJ=206 $X=2812000 $Y=1407900 $D=87
D59 61 63 p_nwd AREA=1972.45 PJ=206 $X=2812000 $Y=1607900 $D=87
D60 61 63 p_nwd AREA=1972.45 PJ=206 $X=2812000 $Y=1807900 $D=87
D61 61 63 p_nwd AREA=1972.45 PJ=206 $X=2812000 $Y=2007900 $D=87
D62 61 63 p_nwd AREA=1972.45 PJ=206 $X=2812000 $Y=2207900 $D=87
D63 61 63 p_nwd AREA=1972.45 PJ=206 $X=2812000 $Y=2407900 $D=87
D64 61 63 p_nwd AREA=2453.64 PJ=203.2 $X=2864500 $Y=609300 $D=87
D65 61 63 p_nwd AREA=2487.45 PJ=206 $X=2864500 $Y=807900 $D=87
D66 GNDDO VDDDO p_nwd AREA=14919.3 PJ=509 $X=105200 $Y=240200 $D=87
D67 57 58 p_nwd AREA=55280.9 PJ=1677.69 $X=2640200 $Y=-44800 $D=87
D68 GNDDO VDDDO p_nwd AREA=6962.8 PJ=206 $X=105200 $Y=557900 $D=87
D69 GNDDO VDDDO p_nwd AREA=6962.8 PJ=206 $X=105200 $Y=757900 $D=87
D70 GNDDO VDDDO p_nwd AREA=6962.8 PJ=206 $X=105200 $Y=957900 $D=87
D71 GNDDO VDDDO p_nwd AREA=6874.92 PJ=271 $X=105200 $Y=1157900 $D=87
D72 GNDDO VDDDO p_nwd AREA=13634.9 PJ=471 $X=105200 $Y=2557900 $D=87
D73 GNDDO VDDDO p_nwd AREA=6874.92 PJ=271 $X=105200 $Y=2359200 $D=87
D74 57 58 p_nwd AREA=39124.5 PJ=1199.69 $X=105200 $Y=34100 $D=87
D75 56 59 p_nwd AREA=39036.6 PJ=1264.69 $X=105200 $Y=2809200 $D=87
D76 56 59 p_nwd AREA=50704.4 PJ=1474.69 $X=2638900 $Y=2977000 $D=87
D77 GNDDO VDDDO p_nwd AREA=6787.04 PJ=336 $X=105200 $Y=1359200 $D=87
D78 GNDDO VDDDO p_nwd AREA=6787.04 PJ=336 $X=105200 $Y=1559200 $D=87
D79 GNDDO VDDDO p_nwd AREA=6787.04 PJ=336 $X=105200 $Y=1759200 $D=87
D80 GNDDO VDDDO p_nwd AREA=6787.04 PJ=336 $X=105200 $Y=1959200 $D=87
D81 GNDDO VDDDO p_nwd AREA=6787.04 PJ=336 $X=105200 $Y=2159200 $D=87
D82 57 58 p_nwd AREA=6962.8 PJ=206 $X=638900 $Y=-44800 $D=87
D83 56 59 p_nwd AREA=6787.04 PJ=336 $X=640200 $Y=2977000 $D=87
D84 57 58 p_nwd AREA=6962.8 PJ=206 $X=838900 $Y=-44800 $D=87
D85 56 59 p_nwd AREA=6874.92 PJ=271 $X=840200 $Y=2977000 $D=87
D86 57 58 p_nwd AREA=6962.8 PJ=206 $X=1038900 $Y=-44800 $D=87
D87 56 59 p_nwd AREA=6962.8 PJ=206 $X=1038900 $Y=2977000 $D=87
D88 57 58 p_nwd AREA=6962.8 PJ=206 $X=1238900 $Y=-44800 $D=87
D89 56 59 p_nwd AREA=6962.8 PJ=206 $X=1238900 $Y=2977000 $D=87
D90 57 58 p_nwd AREA=6962.8 PJ=206 $X=1438900 $Y=-44800 $D=87
D91 56 59 p_nwd AREA=6962.8 PJ=206 $X=1438900 $Y=2977000 $D=87
D92 57 58 p_nwd AREA=6962.8 PJ=206 $X=1638900 $Y=-44800 $D=87
D93 56 59 p_nwd AREA=6962.8 PJ=206 $X=1638900 $Y=2977000 $D=87
D94 57 58 p_nwd AREA=6962.8 PJ=206 $X=1838900 $Y=-44800 $D=87
D95 56 59 p_nwd AREA=6962.8 PJ=206 $X=1838900 $Y=2977000 $D=87
D96 57 58 p_nwd AREA=6962.8 PJ=206 $X=2038900 $Y=-44800 $D=87
D97 56 59 p_nwd AREA=6962.8 PJ=206 $X=2038900 $Y=2977000 $D=87
D98 57 58 p_nwd AREA=6874.92 PJ=271 $X=2238900 $Y=-44800 $D=87
D99 56 59 p_nwd AREA=6962.8 PJ=206 $X=2238900 $Y=2977000 $D=87
D100 57 58 p_nwd AREA=6787.04 PJ=336 $X=2440200 $Y=-44800 $D=87
D101 56 59 p_nwd AREA=6962.8 PJ=206 $X=2438900 $Y=2977000 $D=87
D102 56 59 p_nwd AREA=6787.04 PJ=336 $X=2978000 $Y=609200 $D=87
D103 56 59 p_nwd AREA=6787.04 PJ=336 $X=2978000 $Y=809200 $D=87
D104 56 59 p_nwd AREA=6874.92 PJ=271 $X=2978000 $Y=1009200 $D=87
D105 56 59 p_nwd AREA=6962.8 PJ=206 $X=2978000 $Y=1207900 $D=87
D106 56 59 p_nwd AREA=6962.8 PJ=206 $X=2978000 $Y=1407900 $D=87
D107 56 59 p_nwd AREA=6962.8 PJ=206 $X=2978000 $Y=1607900 $D=87
D108 56 59 p_nwd AREA=6962.8 PJ=206 $X=2978000 $Y=1807900 $D=87
D109 56 59 p_nwd AREA=6962.8 PJ=206 $X=2978000 $Y=2007900 $D=87
D110 56 59 p_nwd AREA=6962.8 PJ=206 $X=2978000 $Y=2207900 $D=87
D111 56 59 p_nwd AREA=6962.8 PJ=206 $X=2978000 $Y=2407900 $D=87
D112 60 62 p_nwd AREA=28.725 PJ=3 $X=2812000 $Y=557900 $D=87
D113 57 58 p_nwd AREA=114.92 PJ=71 $X=2978000 $Y=557900 $D=87
X122 VDDDR GNDDR VDDDR GNDDO VDDDO RESET_L 100 ICP $T=5400 559400 0 270 $X=5400 $Y=459150
X123 VDDDR GNDDR VDDDR GNDDO VDDDO SPI_MOSI 99 ICP $T=5400 759400 0 270 $X=5400 $Y=659150
X124 VDDDR GNDDR VDDDR GNDDO VDDDO SPI_CS 98 ICP $T=5400 959400 0 270 $X=5400 $Y=859150
X125 VDDDR GNDDR VDDDR GNDDO VDDDO SPI_CLK 97 ICP $T=5400 1159400 0 270 $X=5400 $Y=1059150
X126 VDDDR GNDDR VDDDR GNDDO VDDDO CLK4K 1 ICP $T=5400 2559400 0 270 $X=5400 $Y=2459150
X127 VDDDR GNDDR VDDDR GNDDO VDDDO VDD3OP $T=5400 1359400 0 270 $X=5400 $Y=1259150
X128 VDDDR GNDDR GNDDO 122 VDD3RP $T=5400 1559400 0 270 $X=5400 $Y=1459748
X129 GNDDR VDDDR GNDDO VDDD VDD3IP $T=5400 1759400 0 270 $X=5400 $Y=1659150
X130 VDDDR GNDDR GNDDO 124 GND3RP $T=5400 1959400 0 270 $X=5400 $Y=1859748
X131 GNDDR GNDDO VDDDO 123 GND3OP $T=5400 2159400 0 270 $X=5400 $Y=2059748
X132 GNDDO GNDD GND3IP $T=5400 2359400 0 270 $X=5400 $Y=2259748
X195 VDDDR GNDDO GNDDR 60 57 62 PWRCUT_DIG_P_DX $T=5400 240400 0 270 $X=106950 $Y=189900
X196 63 56 61 GNDDR GNDDO VDDDR PWRCUT_DIG_P_DX $T=5400 2809400 0 270 $X=106950 $Y=2758900
X197 62 57 60 61 56 63 PWRCUT_DIG_P_DX $T=3145400 559400 0 90 $X=2811950 $Y=558900
X198 3 4 20 10 9 38 26 19 1 119 117 34 115 VDDA 114 23 24 116 29 30
+ 36 31 32 33 118 GNDA 44 120 GNDD VDDD
+ fecg_front_end_f_3 $T=413000 1994400 0 0 $X=405600 $Y=1975400
X199 33 32 31 9 10 20 19 17 100 108 15 16 97 14 11 12 99 18 98 13
+ 102 103 104 105 106 107 GNDD VDDD
+ il2244_dig $T=695400 1612150 0 90 $X=425298 $Y=1626650
X200 5 6 18 12 11 27 22 13 101 VDDAS GNDAS 39 35 14 37 15 16 25 17 112
+ 113 28 VDDD 7 8 40 41 43 GNDD 21 2 1
+ ECG_Front_End $T=364700 151600 0 0 $X=448550 $Y=204450
X201 VDDAS 110 109 GNDAS 21 39 41 28 35 2 113 42 112 27 ECG_BIAS $T=-649950 2027100 0 0 $X=463675 $Y=1145750
X202 62 60 57 58 VINPS 5 APRIO200P $T=540400 -144600 0 0 $X=540150 $Y=-144600
X203 62 60 57 58 VINNS 6 APRIO200P $T=740400 -144600 0 0 $X=740150 $Y=-144600
X204 62 60 57 58 CMS 22 APRIO200P $T=940400 -144600 0 0 $X=940150 $Y=-144600
X205 63 61 56 59 VINP 4 APRIO200P $T=1040400 3144400 0 180 $X=940150 $Y=2809648
X206 62 60 57 58 CMFBS 25 APRIO200P $T=1140400 -144600 0 0 $X=1140150 $Y=-144600
X207 63 61 56 59 VINN 3 APRIO200P $T=1240400 3144400 0 180 $X=1140150 $Y=2809648
X208 62 60 57 58 EXC1S 7 APRIO200P $T=1340400 -144600 0 0 $X=1340150 $Y=-144600
X209 63 61 56 59 CM 26 APRIO200P $T=1440400 3144400 0 180 $X=1340150 $Y=2809648
X210 62 60 57 58 EXC2S 8 APRIO200P $T=1540400 -144600 0 0 $X=1540150 $Y=-144600
X211 63 61 56 59 CMFB 23 APRIO200P $T=1640400 3144400 0 180 $X=1540150 $Y=2809648
X212 62 60 57 58 CVGAS 37 APRIO200P $T=1740400 -144600 0 0 $X=1740150 $Y=-144600
X213 63 61 56 59 EXC1 117 APRIO200P $T=1840400 3144400 0 180 $X=1740150 $Y=2809648
X214 62 60 57 58 CBUFS 40 APRIO200P $T=1940400 -144600 0 0 $X=1940150 $Y=-144600
X215 63 61 56 59 EXC2 119 APRIO200P $T=2040400 3144400 0 180 $X=1940150 $Y=2809648
X216 62 60 57 58 ECGS 43 APRIO200P $T=2140400 -144600 0 0 $X=2140150 $Y=-144600
X217 63 61 56 59 CVGA 36 APRIO200P $T=2240400 3144400 0 180 $X=2140150 $Y=2809648
X218 63 61 56 59 CBUF 120 APRIO200P $T=2440400 3144400 0 180 $X=2340150 $Y=2809648
X219 63 61 56 59 FECG 44 APRIO200P $T=2640400 3144400 0 180 $X=2540150 $Y=2809648
X220 62 60 57 58 VRESS 42 APRIO200P $T=3145400 459400 0 90 $X=2810648 $Y=459150
X221 63 61 56 59 VPI 125 APRIO200P $T=3145400 1109400 0 90 $X=2810648 $Y=1109150
X222 63 61 56 59 POT_OUT 126 APRIO200P $T=3145400 1309400 0 90 $X=2810648 $Y=1309150
X223 63 61 56 59 TIA_IN 127 APRIO200P $T=3145400 1509400 0 90 $X=2810648 $Y=1509150
X224 63 61 56 59 RE 128 APRIO200P $T=3145400 1709400 0 90 $X=2810648 $Y=1709150
X225 63 61 56 59 CE 129 APRIO200P $T=3145400 1909400 0 90 $X=2810648 $Y=1909150
X226 63 61 56 59 WE 130 APRIO200P $T=3145400 2109400 0 90 $X=2810648 $Y=2109150
X227 63 61 56 59 V_EC 131 APRIO200P $T=3145400 2309400 0 90 $X=2810648 $Y=2309150
X228 63 61 56 59 VRES 121 APRIO200P $T=3145400 2509400 0 90 $X=2810648 $Y=2509150
X229 63 61 56 59 GNDA AGND3ALLP $T=640400 3144400 0 180 $X=540150 $Y=2809548
X230 62 60 57 58 GNDAS AGND3ALLP $T=2540400 -144600 0 0 $X=2540150 $Y=-144600
X231 63 61 56 59 GNDA AGND3ALLP $T=3145400 709400 0 90 $X=2810548 $Y=709150
X232 63 61 56 59 VDDA AVDD3ALLP $T=840400 3144400 0 180 $X=740150 $Y=2810298
X233 62 60 57 58 VDDAS AVDD3ALLP $T=2340400 -144600 0 0 $X=2340150 $Y=-144600
X234 63 61 56 59 VDDA AVDD3ALLP $T=3145400 909400 0 90 $X=2811298 $Y=909150
X235 74 77 108 111 VDDA 121 114 115 116 30 29 118 34 38 24 GNDA fbias_bias2_f $T=767650 1609500 0 0 $X=767425 $Y=1608900
.ENDS
***************************************
