ADE simulation setup
Test VT26_TOP_top_tb_1: VT26_TOP/top_tb/config, simulator ams
  Models: /opt/pdk/ams/410/spectre/c35/soac/processOption.scs, /opt/pdk/ams/410/spectre/c35/soac/cmos53.scs[cmostm], /opt/pdk/ams/410/spectre/c35/soac/res.scs[restm], /opt/pdk/ams/410/spectre/c35/soac/cap.scs[captm], /opt/pdk/ams/410/spectre/c35/soac/bip.scs[biptm], /opt/pdk/ams/410/spectre/c35/soac/ind.scs[indtm], /opt/pdk/ams/410/spectre/c35/soac/esddiode.scs[esddiodetm]
  Variables: FC = 4k; VCM_AC = 0; VCM_AMP = 0; VCM_DC = 1.6; VIN_AC = 1; VIN_AMP = 1m; VIN_DC = 0; VIN_FREQ = 50
  Temperature: 27
  Files: definitions /opt/pdk/ams/410/spectre/c35/soac/soac.scs
  Analysis dc: (saves the operating point)
Test VT26_TOP_top_tb_TRAN_VDD_BOR: VT26_TOP/top_tb/config, simulator ams
  Models: /opt/pdk/ams/410/spectre/c35/processOption.scs, /opt/pdk/ams/410/spectre/c35/cmos53.scs[cmostm], /opt/pdk/ams/410/spectre/c35/res.scs[restm], /opt/pdk/ams/410/spectre/c35/cap.scs[captm], /opt/pdk/ams/410/spectre/c35/bip.scs[biptm], /opt/pdk/ams/410/spectre/c35/ind.scs[indtm], /opt/pdk/ams/410/spectre/c35/esddiode.scs[esddiodetm]
  Variables: VDD_PULSE_BOR = -500m; VDD_PULSE = 3.3; VDD_PW = 9; VDD_SR = 1u; VDD = 0; FC = 4k; VCM_AC = 0; VCM_AMP = 0; VCM_DC = 1.6; VIN_AC = 1; VIN_AMP = 1m; VIN_DC = 0; VIN_FREQ = 50
  Temperature: 27
  Simulator options: reltol=100e-6 homotopy=all limit=delta additionalArgs=enable_pre_ver=yes ignorezerovar=yes
  Files: definitions /opt/pdk/ams/410/spectre/c35/soac/soac.scs
  Analysis tran: stop=4 errpreset=conservative infotimes=("160u")
  Signals: /RESET_L, /SPI_CLK, /CPI_CS, /SPI_MOSI, /I0/fECG_filter<2:0>, /I0/fECG_gain<2:0>, /I0/CMFB_en, /I0/porl, /FECG, /I0/vinp, /I0/vinn, /I0/I2/VIA, /I0/I2/VLF1, /I0/I2/VGA, /I0/I2/VLF2
Test VT26_TOP_top_tb_DC: VT26_TOP/topsy_tb/config, simulator ams
  Models: /opt/pdk/ams/410/spectre/c35/processOption.scs, /opt/pdk/ams/410/spectre/c35/cmos53.scs[cmostm], /opt/pdk/ams/410/spectre/c35/res.scs[restm], /opt/pdk/ams/410/spectre/c35/cap.scs[captm], /opt/pdk/ams/410/spectre/c35/bip.scs[biptm], /opt/pdk/ams/410/spectre/c35/ind.scs[indtm], /opt/pdk/ams/410/spectre/c35/esddiode.scs[esddiodetm]
  Variables: VDD_PULSE_BOR = 0; VDD_PULSE = 0; VDD_PW = 0.5; VDD_SR = 1u; VDD = 3.3; FC = 4k; VCM_AC = 0; VCM_AMP = 0; VCM_DC = 1.6; VIN_AC = 1; VIN_AMP = 1m; VIN_DC = 0; VIN_FREQ = 50
  Temperature: 27
  Simulator options: reltol=100e-6 homotopy=all limit=delta additionalArgs=enable_pre_ver=yes ignorezerovar=yes
  Files: definitions /opt/pdk/ams/410/spectre/c35/soac/soac.scs
  Analysis tran: stop=200u errpreset=conservative infotimes=("200u")
Test VT26_TOP_top_tb_TRAN: VT26_TOP/topsy_tb/config, simulator ams
  Models: /opt/pdk/ams/410/spectre/c35/processOption.scs, /opt/pdk/ams/410/spectre/c35/cmos53.scs[cmostm], /opt/pdk/ams/410/spectre/c35/res.scs[restm], /opt/pdk/ams/410/spectre/c35/cap.scs[captm], /opt/pdk/ams/410/spectre/c35/bip.scs[biptm], /opt/pdk/ams/410/spectre/c35/ind.scs[indtm], /opt/pdk/ams/410/spectre/c35/esddiode.scs[esddiodetm]
  Variables: VDD_PULSE_BOR = 0; VDD_PULSE = 0; VDD_PW = 0.5; VDD_SR = 1u; VDD = 3.3; FC = 4k; VCM_AC = 0; VCM_AMP = 0; VCM_DC = 1.6; VIN_AC = 1; VIN_AMP = 0.25m; VIN_DC = 0; VIN_FREQ = 50
  Temperature: 27
  Simulator options: reltol=100e-6 homotopy=all limit=delta additionalArgs=enable_pre_ver=yes ignorezerovar=yes
  Files: definitions /opt/pdk/ams/410/spectre/c35/soac/soac.scs
  Analysis tran: stop=200m errpreset=conservative infotimes=("160u")
  Signals: /RESET_L, /SPI_CLK, /CPI_CS, /SPI_MOSI, /I0/fECG_filter<2:0>, /I0/fECG_gain<2:0>, /I0/CMFB_en, /I0/porl, /FECG, /I0/vinp, /I0/vinn, /I0/I2/VIA, /I0/I2/VLF1, /I0/I2/VGA, /I0/I2/VLF2, /GNDA, /ECG, /I0/ECG_filter<2:0>, /I0/ECG_gain<3:0>, /I0/CMFB_ens, /I0/I19/VIA, /I0/I19/VLF1, /I0/I19/VGA, /I0/I19/VLF2
Test VT26_TOP_top_tb_TRAN_GAIN_ECG: VT26_TOP/topsy_tb/config, simulator ams
  Models: /opt/pdk/ams/410/spectre/c35/processOption.scs, /opt/pdk/ams/410/spectre/c35/cmos53.scs[cmostm], /opt/pdk/ams/410/spectre/c35/res.scs[restm], /opt/pdk/ams/410/spectre/c35/cap.scs[captm], /opt/pdk/ams/410/spectre/c35/bip.scs[biptm], /opt/pdk/ams/410/spectre/c35/ind.scs[indtm], /opt/pdk/ams/410/spectre/c35/esddiode.scs[esddiodetm]
  Variables: VDD_PULSE_BOR = 0; VDD_PULSE = 0; VDD_PW = 0.5; VDD_SR = 1u; VDD = 3.3; FC = 4k; VCM_AC = 0; VCM_AMP = 0; VCM_DC = 1.6; VIN_AC = 1; VIN_AMP = 0.25m; VIN_DC = 0; VIN_FREQ = 50
  Temperature: 27
  Simulator options: reltol=100e-6 homotopy=all limit=delta additionalArgs=enable_pre_ver=yes ignorezerovar=yes
  Files: definitions /opt/pdk/ams/410/spectre/c35/soac/soac.scs
  Analysis tran: stop=200m errpreset=conservative infotimes=("160u")
  Signals: /RESET_L, /SPI_CLK, /CPI_CS, /SPI_MOSI, /I0/fECG_filter<2:0>, /I0/fECG_gain<2:0>, /I0/CMFB_en, /I0/porl, /FECG, /I0/vinp, /I0/vinn, /I0/I2/VIA, /I0/I2/VLF1, /I0/I2/VGA, /I0/I2/VLF2, /GNDA, /ECG, /I0/ECG_filter<2:0>, /I0/ECG_gain<3:0>, /I0/CMFB_ens, /I0/I19/VIA, /I0/I19/VLF1, /I0/I19/VGA, /I0/I19/VLF2
Test VT26_TOP_top_tb_TRAN_VDD: VT26_TOP/topsy_tb/config, simulator ams
  Models: /opt/pdk/ams/410/spectre/c35/processOption.scs, /opt/pdk/ams/410/spectre/c35/cmos53.scs[cmostm], /opt/pdk/ams/410/spectre/c35/res.scs[restm], /opt/pdk/ams/410/spectre/c35/cap.scs[captm], /opt/pdk/ams/410/spectre/c35/bip.scs[biptm], /opt/pdk/ams/410/spectre/c35/ind.scs[indtm], /opt/pdk/ams/410/spectre/c35/esddiode.scs[esddiodetm]
  Variables: VDD_PULSE_BOR = 0; VDD_PULSE = 3.3; VDD_PW = 9; VDD_SR = 1m; VDD = 0; FC = 4k; VCM_AC = 0; VCM_AMP = 0; VCM_DC = 1.6; VIN_AC = 1; VIN_AMP = 1m; VIN_DC = 0; VIN_FREQ = 50
  Temperature: 27
  Simulator options: reltol=100e-6 homotopy=all limit=delta additionalArgs=enable_pre_ver=yes ignorezerovar=yes
  Files: definitions /opt/pdk/ams/410/spectre/c35/soac/soac.scs
  Analysis tran: stop=1 errpreset=conservative infotimes=("160u")
  Signals: /RESET_L, /SPI_CLK, /CPI_CS, /SPI_MOSI, /I0/fECG_filter<2:0>, /I0/fECG_gain<2:0>, /I0/CMFB_en, /I0/porl, /FECG, /I0/vinp, /I0/vinn, /I0/I2/VIA, /I0/I2/VLF1, /I0/I2/VGA, /I0/I2/VLF2, /ECG, /I0/I19/VIA, /I0/I19/VLF1, /I0/I19/VGA, /I0/I19/VLF2
Test VT26_TOP_top_tb_TRAN_FILTER_ECG: VT26_TOP/topsy_tb/config, simulator ams
  Models: /opt/pdk/ams/410/spectre/c35/processOption.scs, /opt/pdk/ams/410/spectre/c35/cmos53.scs[cmostm], /opt/pdk/ams/410/spectre/c35/res.scs[restm], /opt/pdk/ams/410/spectre/c35/cap.scs[captm], /opt/pdk/ams/410/spectre/c35/bip.scs[biptm], /opt/pdk/ams/410/spectre/c35/ind.scs[indtm], /opt/pdk/ams/410/spectre/c35/esddiode.scs[esddiodetm]
  Variables: VDD_PULSE_BOR = 0; VDD_PULSE = 0; VDD_PW = 0.5; VDD_SR = 1u; VDD = 3.3; FC = 4k; VCM_AC = 0; VCM_AMP = 0; VCM_DC = 1.6; VIN_AC = 1; VIN_AMP = 1m; VIN_DC = 0; VIN_FREQ = 800
  Temperature: 27
  Simulator options: reltol=100e-6 homotopy=all limit=delta additionalArgs=enable_pre_ver=yes ignorezerovar=yes
  Files: definitions /opt/pdk/ams/410/spectre/c35/soac/soac.scs
  Analysis tran: stop=160m errpreset=conservative infotimes=("160u")
  Signals: /RESET_L, /SPI_CLK, /CPI_CS, /SPI_MOSI, /I0/fECG_filter<2:0>, /I0/fECG_gain<2:0>, /I0/CMFB_en, /I0/porl, /FECG, /I0/vinp, /I0/vinn, /I0/I2/VIA, /I0/I2/VLF1, /I0/I2/VGA, /I0/I2/VLF2, /GNDA, /ECG, /I0/ECG_filter<2:0>, /I0/ECG_gain<3:0>, /I0/CMFB_ens, /I0/I19/VIA, /I0/I19/VLF1, /I0/I19/VGA, /I0/I19/VLF2
Test VT26_TOP_top_tb_TRAN_CMFB: VT26_TOP/topsy_cmfb_tb/config, simulator ams
  Models: /opt/pdk/ams/410/spectre/c35/processOption.scs, /opt/pdk/ams/410/spectre/c35/cmos53.scs[cmostm], /opt/pdk/ams/410/spectre/c35/res.scs[restm], /opt/pdk/ams/410/spectre/c35/cap.scs[captm], /opt/pdk/ams/410/spectre/c35/bip.scs[biptm], /opt/pdk/ams/410/spectre/c35/ind.scs[indtm], /opt/pdk/ams/410/spectre/c35/esddiode.scs[esddiodetm]
  Variables: VDD_PULSE_BOR = 0; VDD_PULSE = 0; VDD_PW = 0.5; VDD_SR = 1u; VDD = 3.3; FC = 4k; VCM_AC = 0; VCM_AMP = 0; VCM_DC = 1.6; VIN_AC = 1; VIN_AMP = 0; VIN_DC = 0; VIN_FREQ = 50
  Temperature: 27
  Simulator options: reltol=100e-6 homotopy=all limit=delta additionalArgs=enable_pre_ver=yes ignorezerovar=yes
  Files: definitions /opt/pdk/ams/410/spectre/c35/soac/soac.scs
  Analysis tran: stop=200m errpreset=conservative infotimes=("160u")
  Analysis dc: (saves the operating point)
  Signals: /VINP, /VINN, /CMFB, /CM, /FECG, /ECG, /VINPS, /VINNS, /CMS, /CMFBS
