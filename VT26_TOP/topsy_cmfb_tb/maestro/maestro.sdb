ADE simulation setup
Run mode: Single Run, Sweeps and Corners
Tests:
  VT26_TOP_top_tb_DC (off): VT26_TOP/topsy_tb/config, simulator ams
    Variables: FC = 4k; VCM_AC = 0; VCM_AMP = 0; VCM_DC = 1.6; VIN_AC = 1; VIN_AMP = 1m; VIN_DC = 0; VIN_FREQ = 50; VDD = 3.3; VDD_PULSE = 0; VDD_PW = 0.5; VDD_SR = 1u; VDD_PULSE_BOR = 0
  VT26_TOP_top_tb_TRAN (off): VT26_TOP/topsy_tb/config, simulator ams
    Variables: FC = 4k; VCM_AC = 0; VCM_AMP = 0; VCM_DC = 1.6; VIN_AC = 1; VIN_AMP = 0.25m; VIN_DC = 0; VIN_FREQ = 50; VDD = 3.3; VDD_PULSE = 0; VDD_PW = 0.5; VDD_SR = 1u; VDD_PULSE_BOR = 0
    Outputs: /RESET_L; /SPI_CLK; /CPI_CS; /SPI_MOSI; /FECG
  VT26_TOP_top_tb_TRAN_VDD (off): VT26_TOP/topsy_tb/config, simulator ams
    Variables: FC = 4k; VCM_AC = 0; VCM_AMP = 0; VCM_DC = 1.6; VIN_AC = 1; VIN_AMP = 1m; VIN_DC = 0; VIN_FREQ = 50; VDD = 0; VDD_PULSE = 3.3; VDD_PW = 9; VDD_SR = 1m; VDD_PULSE_BOR = 0
    Outputs: /RESET_L; /SPI_CLK; /CPI_CS; /SPI_MOSI; /FECG
  VT26_TOP_top_tb_TRAN_VDD_BOR (off): VT26_TOP/topsy_tb/config, simulator ams
    Variables: FC = 4k; VCM_AC = 0; VCM_AMP = 0; VCM_DC = 1.6; VIN_AC = 1; VIN_AMP = 1m; VIN_DC = 0; VIN_FREQ = 50; VDD = 0; VDD_PULSE = 3.3; VDD_PW = 9; VDD_SR = 1u; VDD_PULSE_BOR = -500m
    Outputs: /RESET_L; /SPI_CLK; /CPI_CS; /SPI_MOSI; /FECG
  VT26_TOP_top_tb_TRAN_GAIN_ECG (off): VT26_TOP/topsy_tb/config, simulator ams
    Variables: FC = 4k; VCM_AC = 0; VCM_AMP = 0; VCM_DC = 1.6; VIN_AC = 1; VIN_AMP = 0.25m; VIN_DC = 0; VIN_FREQ = 50; VDD = 3.3; VDD_PULSE = 0; VDD_PW = 0.5; VDD_SR = 1u; VDD_PULSE_BOR = 0
    Outputs: /RESET_L; /SPI_CLK; /CPI_CS; /SPI_MOSI; /FECG
  VT26_TOP_top_tb_TRAN_FILTER_ECG (off): VT26_TOP/topsy_tb/config, simulator ams
    Variables: FC = 4k; VCM_AC = 0; VCM_AMP = 0; VCM_DC = 1.6; VIN_AC = 1; VIN_AMP = 1m; VIN_DC = 0; VIN_FREQ = 800; VDD = 3.3; VDD_PULSE = 0; VDD_PW = 0.5; VDD_SR = 1u; VDD_PULSE_BOR = 0
    Outputs: /RESET_L; /SPI_CLK; /CPI_CS; /SPI_MOSI; /FECG
  VT26_TOP_top_tb_TRAN_CMFB: VT26_TOP/topsy_cmfb_tb/config, simulator ams
    Variables: FC = 4k; VCM_AC = 0; VCM_AMP = 0; VCM_DC = 1.6; VIN_AC = 1; VIN_AMP = 0; VIN_DC = 0; VIN_FREQ = 50; VDD = 3.3; VDD_PULSE = 0; VDD_PW = 0.5; VDD_SR = 1u; VDD_PULSE_BOR = 0; BIO_VB = 1.7; BIO_VB_PULSE = 0; Idc = 0; Iin_TIA_AC = 0; Ipulse = 0; R_ct = 500k
Global variables:
  Ce_sg = 10p
  Csg_tg = 10p
  VS_CM = 14.14
  RL = 51k
  VIN_OFF_DC = 300m
