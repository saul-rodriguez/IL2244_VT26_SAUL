ADE simulation setup
Run mode: Monte Carlo Sampling
Tests:
  IN (off): FECG/fecg_vga_pss_tb/schematic, simulator spectre
    Outputs: output_noise_Vrms; d2_dB; VOUT2_mag
  IN_MC: FECG/fecg_vga_pss_tb/schematic, simulator spectre
    Outputs: output_noise_Vrms; d2_dB; VOUT2_mag
Global variables:
  S0 = 3.3
  S1 = 0
  S2 = 0
  VIN_AMP = 0 (off)
  VIN_FREQ = 50
  VIN_STEP = 0 (off)
  VDD = 3.3 (off)
  VDD_STEP = 0 (off)
Corners (all switched off):
  model folders: /opt/pdk/ams/410/spectre/c35
  every corner: /opt/pdk/ams/410/spectre/c35/processOption.scs, /opt/pdk/ams/410/spectre/c35/cmos53.scs[cmoswo cmoswp cmosws cmoswz], /opt/pdk/ams/410/spectre/c35/bip.scs[biptm], /opt/pdk/ams/410/spectre/c35/ind.scs[indtm], /opt/pdk/ams/410/spectre/c35/esddiode.scs[esddiodetm]
  CMOS (off): res.scs[restm], cap.scs[captm]
  CMOS_VDD (off): VDD=2.97 3.63; res.scs[restm], cap.scs[captm]
  CMOS_VDD_TEMP (off): temperature=-40 85; VDD=2.97 3.63; res.scs[restm], cap.scs[captm]
  CMOS_RES_CAP_VDD_TEMP (off): temperature=-40 85; VDD=2.97 3.63; res.scs[reswp resws], cap.scs[capwp capws]
  CMOS_RES_CAP_TEMP: temperature=-40 85; res.scs[reswp resws], cap.scs[capwp capws]
Monte Carlo Sampling options: mcmethod=all, mcnumpoints=100, parasiticanalysis=0
