ADE simulation setup
Run mode: Single Run, Sweeps and Corners
Tests:
  VIN: FECG/buffer_tb/schematic, simulator spectre
  VDD (off): FECG/buffer_tb/schematic, simulator spectre
  VIN_MC (off): FECG/buffer_tb/schematic, simulator spectre
Global variables:
  VCM = 1.6
  VDD = 0 (off)
  VIN_PULSE = 10m (off)
  VDD_PULSE = 0 (off)
  VDD_RT = 1u (off)
Corners (all switched off):
  model folders: /opt/pdk/ams/410/spectre/c35
  every corner: /opt/pdk/ams/410/spectre/c35/processOption.scs, /opt/pdk/ams/410/spectre/c35/cmos53.scs[cmoswo cmoswp cmosws cmoswz], /opt/pdk/ams/410/spectre/c35/bip.scs[biptm], /opt/pdk/ams/410/spectre/c35/ind.scs[indtm], /opt/pdk/ams/410/spectre/c35/esddiode.scs[esddiodetm]
  CMOS (off): res.scs[restm], cap.scs[captm]
  CMOS_VDD (off): VDD=2.97 3.63; res.scs[restm], cap.scs[captm]
  CMOS_VDD_TEMP (off): temperature=-40 85; VDD=2.97 3.63; res.scs[restm], cap.scs[captm]
  CMOS_RES_CAP_VDD_TEMP (off): temperature=-40 85; VDD=2.97 3.63; res.scs[reswp resws], cap.scs[capwp capws]
  CMOS_RES_CAP_TEMP: temperature=-40 85; res.scs[reswp resws], cap.scs[capwp capws]
