ADE simulation setup
Run mode: Single Run, Sweeps and Corners
Tests:
  IN: FECG/gmc_lpf_tb/schematic, simulator spectre
    Outputs: Fundamental_dB; harm_2nd_dB; d2_dB; Bandwidth
Global variables:
  DC_IN = 1.5
  VIN_AMPV = 0.5
  VIN_DC = 0
  VDD = 3.3
  F0 = 3.3
  F1 = 3.3
  F2 = 0
Corners (all switched off):
  model folders: /opt/pdk/ams/410/spectre/c35
  every corner: /opt/pdk/ams/410/spectre/c35/processOption.scs, /opt/pdk/ams/410/spectre/c35/cmos53.scs[cmoswo cmoswp cmosws cmoswz], /opt/pdk/ams/410/spectre/c35/bip.scs[biptm], /opt/pdk/ams/410/spectre/c35/ind.scs[indtm], /opt/pdk/ams/410/spectre/c35/esddiode.scs[esddiodetm]
  CMOS (off): res.scs[restm], cap.scs[captm]
  CMOS_VDD (off): VDD=2.97 3.63; res.scs[restm], cap.scs[captm]
  CMOS_VDD_TEMP (off): temperature=-40 85; VDD=2.97 3.63; res.scs[restm], cap.scs[captm]
  CMOS_RES_CAP_VDD_TEMP (off): temperature=-40 85; VDD=2.97 3.63; res.scs[reswp resws], cap.scs[capwp capws]
  CMOS_RES_CAP_TEMP: temperature=-40 85; res.scs[reswp resws], cap.scs[capwp capws]
