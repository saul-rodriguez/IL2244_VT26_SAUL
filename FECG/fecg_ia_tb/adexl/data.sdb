ADE simulation setup
Run mode: Monte Carlo Sampling
Tests:
  ECG_IA:ecg_ia_tb:1 (off): FECG/fecg_ia_tb/schematic, simulator spectre
    Outputs: /VOUT1; /I2/INT; /VDDA; Fundamental_dB; harmonic(db(vh('pss "/VOUT")) 1); harmionic_1_dB; d2; Fundamental_V
  Noise (off): FECG/fecg_ia_tb/schematic, simulator spectre
    Outputs: transient_noise; Integrated_noise_V
  MC: FECG/fecg_ia_tb/schematic, simulator spectre
    Outputs: histogram2D(value(mag(VF("/VOUT")) 50) 10 "standard" "both" t); value(mag(VF("/VOUT")) 50); Fundamental_VOUT1_dB; d2_dB; VOUT1; VOUT1_DC_PSS; VOUT_pss; DC Vout; VOUT1_mag; GAIN_CM_dB_50Hz; Fundamental_VOUT1_V
Global variables:
  VCM_AC = 1
  VCM_DC = 1.6
  VDD = 3.3 (off)
  VIN_AC = 1
  VIN_DC = 0 (off)
  FC = 4k (off)
  VIN_AMP = 0 (off)
  VIN_FREQ = 0 (off)
  VIN_STEP = 0 (off)
  VDD_STEP = 0 (off)
  VCM_AMP = 0 (off)
  VDD_PERIOD = 0
  VDD_PULSE = 0
  VDD_RS = 1n
Corners (all switched off):
  model folders: /opt/pdk/ams/410/spectre/c35
  every corner: /opt/pdk/ams/410/spectre/c35/processOption.scs, /opt/pdk/ams/410/spectre/c35/cmos53.scs[cmoswo cmoswp cmosws cmoswz], /opt/pdk/ams/410/spectre/c35/cap.scs[captm], /opt/pdk/ams/410/spectre/c35/bip.scs[biptm], /opt/pdk/ams/410/spectre/c35/ind.scs[indtm], /opt/pdk/ams/410/spectre/c35/esddiode.scs[esddiodetm]
  CMOS (off): res.scs[restm]
  CMOS_VDD (off): VDD=2.97 3.63; res.scs[restm]
  CMOS_VDD_TEMP (off): temperature=-40 85; VDD=2.97 3.63; res.scs[restm]
  CMOS_RES_VDD_TEMP: temperature=-40 85; VDD=2.97 3.63; res.scs[reswp resws]
Monte Carlo Sampling options: mcmethod=all, mcnumpoints=1, parasiticanalysis=0, ignoremode=default
