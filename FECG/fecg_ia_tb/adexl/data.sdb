ADE simulation setup
Run mode: Single Run, Sweeps and Corners
Tests:
  ECG_IA:ecg_ia_tb:1 (off): FECG/fecg_ia_tb/schematic, simulator spectre
    Outputs: /VOUT1; /I2/INT; /VDDA; Fundamental_dB; harmonic(db(vh('pss "/VOUT")) 1); harmionic_1_dB; d2; Fundamental_V
  Noise: FECG/fecg_ia_tb/schematic, simulator spectre
    Outputs: transient_noise; Integrated_noise_V
  MC (off): FECG/fecg_ia_tb/schematic, simulator spectre
    Outputs: histogram2D(value(mag(VF("/VOUT")) 50) 10 "standard" "both" t); value(mag(VF("/VOUT")) 50); Fundamental_dB
Global variables:
  VCM_AC = 1
  VCM_DC = 1.6
  VDD = 3.3 (off)
  VIN_AC = 1
  VIN_DC = 0 (off)
  FC = 2k (off)
  VIN_AMP = 0 (off)
  VIN_FREQ = 0 (off)
  VIN_STEP = 0 (off)
  VDD_STEP = 0 (off)
  VCM_AMP = 0 (off)
Corners (all switched off):
  every corner: /opt/pdk/ams/410/spectre/c35/processOption.scs, /opt/pdk/ams/410/spectre/c35/cmos53.scs[cmoswo cmoswp cmosws cmoswz], /opt/pdk/ams/410/spectre/c35/res.scs[restm], /opt/pdk/ams/410/spectre/c35/cap.scs[captm], /opt/pdk/ams/410/spectre/c35/bip.scs[biptm], /opt/pdk/ams/410/spectre/c35/ind.scs[indtm], /opt/pdk/ams/410/spectre/c35/esddiode.scs[esddiodetm]
  CMOS_VDD (off): VDD=2.97 3.63
  CMOS_VDD_TEMP: temperature=-40 85; VDD=2.97 3.63
