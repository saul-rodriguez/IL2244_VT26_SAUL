ADE simulation setup
Test PSS_VIN: FECG/fecg_front_end_tb/schematic, simulator spectre
  Models: /opt/pdk/ams/410/spectre/c35/processOption.scs, /opt/pdk/ams/410/spectre/c35/cmos53.scs[cmostm], /opt/pdk/ams/410/spectre/c35/res.scs[restm], /opt/pdk/ams/410/spectre/c35/cap.scs[captm], /opt/pdk/ams/410/spectre/c35/bip.scs[biptm], /opt/pdk/ams/410/spectre/c35/ind.scs[indtm], /opt/pdk/ams/410/spectre/c35/esddiode.scs[esddiodetm]
  Variables: F0 = 3.3; F1 = 3.3; F2 = 0; S0 = 1; S1 = 0; S2 = 0; VCM_AMP = 0; VIN_FREQ = 50; VIN_AMP = 0.8m; FC = 4k; VCM_AC = 0; VCM_DC = 1.5; VDD = 3.3; VIN_AC = 1; VIN_DC = 0
  Temperature: 27
  Simulator options: reltol=100e-6 homotopy=all limit=delta additionalArgs=enable_pre_ver=yes ignorezerovar=yes
  Files: definitions /opt/pdk/ams/410/spectre/c35/soac/soac.scs
  Analysis pss: engine=Shooting fund=50 harms=10 errpreset=conservative
  Analysis dc: (saves the operating point)
  Output v /I19/VIA; pss (V) = vtime('pss "/I19/VIA")
  Output v /I19/VLF1; pss (V) = vtime('pss "/I19/VLF1")
  Output v /I19/VGA; pss (V) = vtime('pss "/I19/VGA")
  Output v /I19/VLF2; pss (V) = vtime('pss "/I19/VLF2")
  Output v /VOUT; pss (V) = vtime('pss "/VOUT")
  Output v /VOUT; pss dB20(V) = db(vh('pss "/VOUT"))
  Output VIA_d2_dB = (harmonic(db(vh('pss "/I19/VIA")) 1) - harmonic(db(vh('pss "/I19/VIA")) 2))
  Output VLF1_d2_dB = (harmonic(db(vh('pss "/I19/VLF1")) 1) - harmonic(db(vh('pss "/I19/VLF1")) 2))
  Output VGA_d2_dB = (harmonic(db(vh('pss "/I19/VGA")) 1) - harmonic(db(vh('pss "/I19/VGA")) 2))
  Output VLF2_d2_dB1 = (harmonic(db(vh('pss "/I19/VLF2")) 1) - harmonic(db(vh('pss "/I19/VLF2")) 2))
  Output VOUT_d2_dB = (harmonic(db(vh('pss "/VOUT")) 1) - harmonic(db(vh('pss "/VOUT")) 2))
  Output VOUT_V = harmonic(mag(vh('pss "/VOUT")) 1)
Test PSS_PXF_PNOISE: FECG/fecg_front_end_tb/schematic, simulator spectre
  Models: /opt/pdk/ams/410/spectre/c35/processOption.scs, /opt/pdk/ams/410/spectre/c35/cmos53.scs[cmostm], /opt/pdk/ams/410/spectre/c35/res.scs[restm], /opt/pdk/ams/410/spectre/c35/cap.scs[captm], /opt/pdk/ams/410/spectre/c35/bip.scs[biptm], /opt/pdk/ams/410/spectre/c35/ind.scs[indtm], /opt/pdk/ams/410/spectre/c35/esddiode.scs[esddiodetm]
  Variables: F0 = 3.3; F1 = 3.3; F2 = 0; S0 = 1; S1 = 0; S2 = 0; VCM_AMP = 0; VIN_FREQ = 50; VIN_AMP = 0; FC = 4k; VCM_AC = 0; VCM_DC = 1.5; VDD = 3.3; VIN_AC = 1; VIN_DC = 0
  Temperature: 27
  Simulator options: reltol=100e-6 homotopy=all limit=delta additionalArgs=enable_pre_ver=yes ignorezerovar=yes
  Files: definitions /opt/pdk/ams/410/spectre/c35/soac/soac.scs
  Analysis pxf: start=0.01 stop=100k fund=4K p=/VOUT sweeptype=relative relharmnum=0 sidebands=("0")
  Analysis dc: (saves the operating point)
  Analysis pss: engine=Shooting fund=4K harms=40 errpreset=conservative
  Analysis pnoise: start=0.01 stop=100k dec=20 fund=4K p=/VOUT sweeptype=relative relharmnum=0 maxsideband=10 noisetype=timeaverage
  Output Output_Noise_Vrms = sqrt(totalNoise("pnoise" 0.01 100000 nil))
  Output CM_Gain_dB = db(getData("/V2" ?result "pxf"))
  Output CM_Gain_50Hz = value(leafValue(mag(getData("/V2" ?result "pxf")) "harmonic" 0) 50)
  Output CM_Gain_50Hz_dB = value(leafValue(db(getData("/V2" ?result "pxf")) "harmonic" 0) 50)
  Output Diff_Gain_dB = db(getData("/V7" ?result "pxf"))
  Output Diff_Gain_50Hz = value(leafValue(mag(getData("/V7" ?result "pxf")) "harmonic" 0) 50)
  Output Diff_Gain_50Hz_dB = value(leafValue(db(getData("/V2" ?result "pxf")) "harmonic" 0) 50)
  Output CMRR_50Hz_dB = (value(leafValue(db(getData("/V7" ?result "pxf")) "harmonic" 0) 50) - value(leafValue(db(getData("/V2" ?result "pxf")) "harmonic" 0) 50))
  Output Input_ref_noise_Vrms = (sqrt(totalNoise("pnoise" 0.01 100000 nil)) / value(leafValue(mag(getData("/V7" ?result "pxf")) "harmonic" 0) 50))
  Output Output_noise_Vrms = sqrt(totalNoise("pnoise" 0.01 100000 nil))
Test PSS_TRAN: FECG/fecg_front_end_tran_tb/schematic, simulator spectre
  Models: /opt/pdk/ams/410/spectre/c35/processOption.scs, /opt/pdk/ams/410/spectre/c35/cmos53.scs[cmostm], /opt/pdk/ams/410/spectre/c35/res.scs[restm], /opt/pdk/ams/410/spectre/c35/cap.scs[captm], /opt/pdk/ams/410/spectre/c35/bip.scs[biptm], /opt/pdk/ams/410/spectre/c35/ind.scs[indtm], /opt/pdk/ams/410/spectre/c35/esddiode.scs[esddiodetm]
  Variables: CM_PULSE = 0; VDD_PULSE = 0; VIN_PULSE = 0; F0 = 3.3; F1 = 3.3; F2 = 0; S0 = 1; S1 = 0; S2 = 0; VCM_AMP = 0; VIN_FREQ = 50; VIN_AMP = 0.8m; FC = 2K; VCM_AC = 0; VCM_DC = 1.5; VDD = 3.3; VIN_AC = 1; VIN_DC = 0
  Temperature: 27
  Simulator options: reltol=100e-6 homotopy=all limit=delta additionalArgs=enable_pre_ver=yes ignorezerovar=yes
  Files: definitions /opt/pdk/ams/410/spectre/c35/soac/soac.scs
  Analysis tran: stop=100m errpreset=conservative
  Analysis dc: (saves the operating point)
  Signals: /VOUT, /VCM, /VDDA
Test TRAN_CM: FECG/fecg_front_end_tran_tb/schematic, simulator spectre
  Models: /opt/pdk/ams/410/spectre/c35/processOption.scs, /opt/pdk/ams/410/spectre/c35/cmos53.scs[cmostm], /opt/pdk/ams/410/spectre/c35/res.scs[restm], /opt/pdk/ams/410/spectre/c35/cap.scs[captm], /opt/pdk/ams/410/spectre/c35/bip.scs[biptm], /opt/pdk/ams/410/spectre/c35/ind.scs[indtm], /opt/pdk/ams/410/spectre/c35/esddiode.scs[esddiodetm]
  Variables: CM_PULSE = 0; VDD_PULSE = 0; VIN_PULSE = 10m; F0 = 3.3; F1 = 3.3; F2 = 0; S0 = 1; S1 = 0; S2 = 0; VCM_AMP = 0; VIN_FREQ = 50; VIN_AMP = 0.5m; FC = 2K; VCM_AC = 0; VCM_DC = 1.5; VDD = 3.3; VIN_AC = 1; VIN_DC = 0
  Temperature: 27
  Simulator options: reltol=100e-6 homotopy=all limit=delta additionalArgs=enable_pre_ver=yes ignorezerovar=yes
  Files: definitions /opt/pdk/ams/410/spectre/c35/soac/soac.scs
  Analysis tran: stop=5000m errpreset=conservative
  Analysis dc: (saves the operating point)
  Signals: /VOUT, /VCM, /VDDA, /I19/VIA, /I19/VLF1, /I19/VGA, /I19/VLF2
Test TRAN_VIN: FECG/fecg_front_end_tran_tb/schematic, simulator spectre
  Models: /opt/pdk/ams/410/spectre/c35/processOption.scs, /opt/pdk/ams/410/spectre/c35/cmos53.scs[cmostm], /opt/pdk/ams/410/spectre/c35/res.scs[restm], /opt/pdk/ams/410/spectre/c35/cap.scs[captm], /opt/pdk/ams/410/spectre/c35/bip.scs[biptm], /opt/pdk/ams/410/spectre/c35/ind.scs[indtm], /opt/pdk/ams/410/spectre/c35/esddiode.scs[esddiodetm]
  Variables: CM_PULSE = 0; VDD_PULSE = 0; VIN_PULSE = 0; F0 = 3.3; F1 = 3.3; F2 = 0; S0 = 1; S1 = 0; S2 = 0; VCM_AMP = 0; VIN_FREQ = 50; VIN_AMP = 0.8m; FC = 4k; VCM_AC = 0; VCM_DC = 1.5; VDD = 3.3; VIN_AC = 1; VIN_DC = 0
  Temperature: 27
  Simulator options: reltol=100e-6 homotopy=all limit=delta additionalArgs=enable_pre_ver=yes ignorezerovar=yes
  Files: definitions /opt/pdk/ams/410/spectre/c35/soac/soac.scs
  Analysis tran: stop=100m errpreset=conservative
  Analysis dc: (saves the operating point)
  Signals: /VOUT, /VCM, /VDDA
Test TRAN_VIN_PULSE: FECG/fecg_front_end_tran_tb/config, simulator spectre
  Models: /opt/pdk/ams/410/spectre/c35/processOption.scs, /opt/pdk/ams/410/spectre/c35/cmos53.scs[cmostm], /opt/pdk/ams/410/spectre/c35/res.scs[restm], /opt/pdk/ams/410/spectre/c35/cap.scs[captm], /opt/pdk/ams/410/spectre/c35/bip.scs[biptm], /opt/pdk/ams/410/spectre/c35/ind.scs[indtm], /opt/pdk/ams/410/spectre/c35/esddiode.scs[esddiodetm]
  Variables: CM_PULSE = 0; VDD_PULSE = 0; VIN_PULSE = 1m; F0 = 3.3; F1 = 3.3; F2 = 0; S0 = 1; S1 = 0; S2 = 0; VCM_AMP = 0; VIN_FREQ = 50; VIN_AMP = 0; FC = 1k; VCM_AC = 0; VCM_DC = 1.5; VDD = 3.3; VIN_AC = 1; VIN_DC = 0
  Temperature: 27
  Simulator options: reltol=100e-6 homotopy=all limit=delta additionalArgs=enable_pre_ver=yes ignorezerovar=yes
  Files: definitions /opt/pdk/ams/410/spectre/c35/soac/soac.scs
  Analysis tran: stop=2000m errpreset=conservative
  Analysis dc: (saves the operating point)
  Signals: /VOUT, /VCM, /VDDA, /I19/VIA, /I19/VLF1, /I19/VGA, /I19/VLF2
Test TRAN_VDD_PULSE: FECG/fecg_front_end_tran_tb/config, simulator spectre
  Models: /opt/pdk/ams/410/spectre/c35/processOption.scs, /opt/pdk/ams/410/spectre/c35/cmos53.scs[cmostm], /opt/pdk/ams/410/spectre/c35/res.scs[restm], /opt/pdk/ams/410/spectre/c35/cap.scs[captm], /opt/pdk/ams/410/spectre/c35/bip.scs[biptm], /opt/pdk/ams/410/spectre/c35/ind.scs[indtm], /opt/pdk/ams/410/spectre/c35/esddiode.scs[esddiodetm]
  Variables: CM_PULSE = 0; VDD_PULSE = 3.3; VIN_PULSE = 0; F0 = 3.3; F1 = 3.3; F2 = 0; S0 = 1; S1 = 0; S2 = 0; VCM_AMP = 0; VIN_FREQ = 50; VIN_AMP = 0; FC = 4k; VCM_AC = 0; VCM_DC = 1.5; VDD = 0; VIN_AC = 1; VIN_DC = 0
  Temperature: 27
  Simulator options: reltol=100e-6 homotopy=all limit=delta additionalArgs=enable_pre_ver=yes ignorezerovar=yes
  Files: definitions /opt/pdk/ams/410/spectre/c35/soac/soac.scs
  Analysis tran: stop=1.5 errpreset=conservative
  Analysis dc: (saves the operating point)
  Signals: /VOUT, /VCM, /VDDA, /I19/VIA, /I19/VLF1, /I19/VGA, /I19/VLF2
Test TRAN_VDD_PULSE_MC: FECG/fecg_front_end_tran_tb/config, simulator spectre
  Models: /opt/pdk/ams/410/spectre/c35/processOption.scs, /opt/pdk/ams/410/spectre/c35/cmos53.scs[cmosmc], /opt/pdk/ams/410/spectre/c35/res.scs[resmc], /opt/pdk/ams/410/spectre/c35/cap.scs[capmc], /opt/pdk/ams/410/spectre/c35/bip.scs[bipmc], /opt/pdk/ams/410/spectre/c35/ind.scs[indmc], /opt/pdk/ams/410/spectre/c35/esddiode.scs[esddiodemc]
  Variables: CM_PULSE = 0; VDD_PULSE = 3.3; VIN_PULSE = 0; F0 = 3.3; F1 = 3.3; F2 = 0; S0 = 1; S1 = 0; S2 = 0; VCM_AMP = 0; VIN_FREQ = 50; VIN_AMP = 0; FC = 4k; VCM_AC = 0; VCM_DC = 1.5; VDD = 0; VIN_AC = 1; VIN_DC = 0
  Temperature: 27
  Simulator options: reltol=100e-6 homotopy=all limit=delta additionalArgs=enable_pre_ver=yes ignorezerovar=yes
  Files: definitions /opt/pdk/ams/410/spectre/c35/soac/soac.scs
  Analysis tran: stop=1.5 errpreset=conservative
  Signals: /VOUT, /VCM, /VDDA, /I19/VIA, /I19/VLF1, /I19/VGA, /I19/VLF2
