ADE simulation setup
Test NOISE_CMRR: FECG/fecg_tb/schematic, simulator spectre
  Models: /opt/pdk/ams/410/spectre/c35/processOption.scs, /opt/pdk/ams/410/spectre/c35/cmos53.scs[cmostm], /opt/pdk/ams/410/spectre/c35/res.scs[restm], /opt/pdk/ams/410/spectre/c35/cap.scs[captm], /opt/pdk/ams/410/spectre/c35/bip.scs[biptm], /opt/pdk/ams/410/spectre/c35/ind.scs[indtm], /opt/pdk/ams/410/spectre/c35/esddiode.scs[esddiodetm]
  Variables: F0 = 3.3; F1 = 3.3; F2 = 0; S0 = 3.3; S1 = 0; S2 = 0; VIN_FREQ = 50; VIN_AMP = 0; FC = 4k; VCM_AC = 0; VCM_DC = 1.5; VDD = 3.3; VIN_AC = 1; VIN_DC = 0
  Temperature: 27
  Simulator options: reltol=100e-6 homotopy=all limit=delta additionalArgs=enable_pre_ver=yes ignorezerovar=yes
  Files: definitions /opt/pdk/ams/410/spectre/c35/soac/soac.scs
  Analysis pxf: start=0.01 stop=100k dec=10 fund=4K p=/VOUT sweeptype=relative relharmnum=0 sidebands=("0")
  Analysis dc: (saves the operating point)
  Analysis pss: engine=Shooting fund=4K harms=40 errpreset=conservative
  Analysis pnoise: start=0.01 stop=100k dec=10 fund=4K p=/VOUT sweeptype=relative relharmnum=0 sidebands=("0") noisetype=timeaverage
  Output Output_noise_Vrms = sqrt(totalNoise("pnoise" 0.01 100000 nil))
  Output CM_Gain_dB = db(getData("/V2" ?result "pxf"))
  Output DIFF_Gain_dB = db(getData("/V7" ?result "pxf"))
  Output DIFF_Gain = value(leafValue(mag(getData("/V7" ?result "pxf")) "harmonic" 0) 50)
  Output CM_Gain = value(leafValue(mag(getData("/V2" ?result "pxf")) "harmonic" 0) 50)
  Output CM_Gain_db = value(leafValue(db(getData("/V2" ?result "pxf")) "harmonic" 0) 50)
  Output CMRR_50Hz_dB = (value(leafValue(db(getData("/V7" ?result "pxf")) "harmonic" 0) 50) - value(leafValue(db(getData("/V2" ?result "pxf")) "harmonic" 0) 50))
  Output Input_referred_noise_Vrms = (sqrt(totalNoise("pnoise" 0.01 100000 nil)) / value(leafValue(mag(getData("/V7" ?result "pxf")) "harmonic" 0) 50))
Test NOISE_CMRR_MC: FECG/fecg_tb/schematic, simulator spectre
  Models: /opt/pdk/ams/410/spectre/c35/processOption.scs, /opt/pdk/ams/410/spectre/c35/cmos53.scs[cmosmc], /opt/pdk/ams/410/spectre/c35/res.scs[resmc], /opt/pdk/ams/410/spectre/c35/cap.scs[capmc], /opt/pdk/ams/410/spectre/c35/bip.scs[bipmc], /opt/pdk/ams/410/spectre/c35/ind.scs[indmc], /opt/pdk/ams/410/spectre/c35/esddiode.scs[esddiodemc]
  Variables: F0 = 3.3; F1 = 3.3; F2 = 0; S0 = 3.3; S1 = 0; S2 = 0; VIN_FREQ = 50; VIN_AMP = 0; FC = 4k; VCM_AC = 0; VCM_DC = 1.5; VDD = 3.3; VIN_AC = 1; VIN_DC = 150m
  Temperature: 27
  Simulator options: reltol=100e-6 homotopy=all limit=delta additionalArgs=enable_pre_ver=yes ignorezerovar=yes
  Files: definitions /opt/pdk/ams/410/spectre/c35/soac/soac.scs
  Analysis pxf: start=0.01 stop=100k dec=10 fund=4K p=/VOUT sweeptype=relative relharmnum=0 sidebands=("0")
  Analysis dc: (saves the operating point)
  Analysis pss: engine=Shooting fund=4K harms=40 errpreset=conservative
  Output Output_noise_Vrms = sqrt(totalNoise("pnoise" 0.01 100000 nil))
  Output CM_Gain_dB = db(getData("/V2" ?result "pxf"))
  Output DIFF_Gain_dB = db(getData("/V7" ?result "pxf"))
  Output DIFF_Gain = value(leafValue(mag(getData("/V7" ?result "pxf")) "harmonic" 0) 50)
  Output CM_Gain = value(leafValue(mag(getData("/V2" ?result "pxf")) "harmonic" 0) 50)
  Output CM_Gain_db = value(leafValue(db(getData("/V2" ?result "pxf")) "harmonic" 0) 50)
  Output CMRR_50Hz_dB = (value(leafValue(db(getData("/V7" ?result "pxf")) "harmonic" 0) 50) - value(leafValue(db(getData("/V2" ?result "pxf")) "harmonic" 0) 50))
  Output Input_referred_noise_Vrms = (sqrt(totalNoise("pnoise" 0.01 100000 nil)) / value(leafValue(mag(getData("/V7" ?result "pxf")) "harmonic" 0) 50))
Test IN: FECG/fecg_tb/schematic, simulator spectre
  Models: /opt/pdk/ams/410/spectre/c35/processOption.scs, /opt/pdk/ams/410/spectre/c35/cmos53.scs[cmostm], /opt/pdk/ams/410/spectre/c35/res.scs[restm], /opt/pdk/ams/410/spectre/c35/cap.scs[captm], /opt/pdk/ams/410/spectre/c35/bip.scs[biptm], /opt/pdk/ams/410/spectre/c35/ind.scs[indtm], /opt/pdk/ams/410/spectre/c35/esddiode.scs[esddiodetm]
  Variables: VCM_AMP = 0; F0 = 3.3; F1 = 3.3; F2 = 0; S0 = 3.3; S1 = 0; S2 = 0; VIN_FREQ = 50; VIN_AMP = 0.8m; FC = 4k; VCM_AC = 0; VCM_DC = 1.6; VDD = 3.3; VIN_AC = 1; VIN_DC = 0
  Temperature: 27
  Simulator options: reltol=100e-6 homotopy=all limit=delta additionalArgs=enable_pre_ver=yes ignorezerovar=yes
  Files: definitions /opt/pdk/ams/410/spectre/c35/soac/soac.scs
  Analysis pss: engine=Shooting fund=50 harms=40 errpreset=conservative
  Analysis dc: (saves the operating point)
  Output v /VOUT; pss (V) = vtime('pss "/VOUT")
  Output v /VLF2; pss (V) = vtime('pss "/VLF2")
  Output v /VGA; pss (V) = vtime('pss "/VGA")
  Output v /VLF1; pss (V) = vtime('pss "/VLF1")
  Output v /VIA; pss (V) = vtime('pss "/VIA")
  Output VOUT_V = harmonic(mag(vh('pss "/VOUT")) 1)
  Output d2_VOUT_dB = (harmonic(db(vh('pss "/VOUT")) 1) - harmonic(db(vh('pss "/VOUT")) 2))
  Output d2_VLF2_dB = (harmonic(db(vh('pss "/VLF2")) 1) - harmonic(db(vh('pss "/VLF2")) 2))
  Output d2_VGA_dB = (harmonic(db(vh('pss "/VGA")) 1) - harmonic(db(vh('pss "/VGA")) 2))
  Output d2_VLF1_dB = (harmonic(db(vh('pss "/VLF1")) 1) - harmonic(db(vh('pss "/VLF1")) 2))
  Output d2_VIA_dB = (harmonic(db(vh('pss "/VIA")) 1) - harmonic(db(vh('pss "/VIA")) 2))
Test IN_MC: FECG/fecg_tb/schematic, simulator spectre
  Models: /opt/pdk/ams/410/spectre/c35/processOption.scs, /opt/pdk/ams/410/spectre/c35/cmos53.scs[cmosmc], /opt/pdk/ams/410/spectre/c35/res.scs[resmc], /opt/pdk/ams/410/spectre/c35/cap.scs[capmc], /opt/pdk/ams/410/spectre/c35/bip.scs[bipmc], /opt/pdk/ams/410/spectre/c35/ind.scs[indmc], /opt/pdk/ams/410/spectre/c35/esddiode.scs[esddiodemc]
  Variables: VCM_AMP = 0.1; F0 = 3.3; F1 = 3.3; F2 = 0; S0 = 3.3; S1 = 0; S2 = 0; VIN_FREQ = 50; VIN_AMP = 0; FC = 4k; VCM_AC = 0; VCM_DC = 1.6; VDD = 3.3; VIN_AC = 1; VIN_DC = 50m
  Temperature: 27
  Simulator options: reltol=100e-6 homotopy=all limit=delta additionalArgs=enable_pre_ver=yes ignorezerovar=yes
  Files: definitions /opt/pdk/ams/410/spectre/c35/soac/soac.scs
  Analysis pss: engine=Shooting fund=50 harms=40 errpreset=conservative
  Analysis dc: (saves the operating point)
  Output v /VOUT; pss (V) = vtime('pss "/VOUT")
  Output v /VLF2; pss (V) = vtime('pss "/VLF2")
  Output v /VGA; pss (V) = vtime('pss "/VGA")
  Output v /VLF1; pss (V) = vtime('pss "/VLF1")
  Output v /VIA; pss (V) = vtime('pss "/VIA")
  Output VOUT_V = harmonic(mag(vh('pss "/VOUT")) 1)
  Output d2_VOUT_dB = (harmonic(db(vh('pss "/VOUT")) 1) - harmonic(db(vh('pss "/VOUT")) 2))
  Output d2_VLF2_dB = (harmonic(db(vh('pss "/VLF2")) 1) - harmonic(db(vh('pss "/VLF2")) 2))
  Output d2_VGA_dB = (harmonic(db(vh('pss "/VGA")) 1) - harmonic(db(vh('pss "/VGA")) 2))
  Output d2_VLF1_dB = (harmonic(db(vh('pss "/VLF1")) 1) - harmonic(db(vh('pss "/VLF1")) 2))
  Output d2_VIA_dB = (harmonic(db(vh('pss "/VIA")) 1) - harmonic(db(vh('pss "/VIA")) 2))
Run mode: Single Run, Sweeps and Corners
Corners (all switched off):
  model folders: /opt/pdk/ams/410/spectre/c35
  every corner: /opt/pdk/ams/410/spectre/c35/processOption.scs, /opt/pdk/ams/410/spectre/c35/cmos53.scs[cmoswo cmoswp cmosws cmoswz], /opt/pdk/ams/410/spectre/c35/bip.scs[biptm], /opt/pdk/ams/410/spectre/c35/ind.scs[indtm], /opt/pdk/ams/410/spectre/c35/esddiode.scs[esddiodetm]
  CMOS (off): res.scs[restm], cap.scs[captm]
  CMOS_VDD (off): VDD=2.97 3.63; res.scs[restm], cap.scs[captm]
  CMOS_VDD_TEMP (off): temperature=-40 85; VDD=2.97 3.63; res.scs[restm], cap.scs[captm]
  CMOS_RES_CAP_VDD_TEMP: temperature=-40 85; VDD=2.97 3.63; res.scs[reswp resws], cap.scs[capwp capws]
  CMOS_RES_CAP_TEMP (off): temperature=-40 85; res.scs[reswp resws], cap.scs[capwp capws]
Specs:
  IN / VOUT_V: > 1
  IN / d2_VOUT_dB: > 60
  IN_MC / VOUT_V: > 1
  IN_MC / d2_VOUT_dB: > 60
  NOISE_CMRR / Input_referred_noise_Vrms: < 1u
  NOISE_CMRR_MC / Input_referred_noise_Vrms: < 1u
Disabled tests: IN_MC, NOISE_CMRR, NOISE_CMRR_MC
