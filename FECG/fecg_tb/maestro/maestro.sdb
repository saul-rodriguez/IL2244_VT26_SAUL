ADE simulation setup
Run mode: Single Run, Sweeps and Corners
Tests:
  IN: FECG/fecg_tb/schematic, simulator spectre
    Variables: VIN_FREQ = 50; VIN_AMP = 0.8m; FC = 4k; VCM_AC = 0; VCM_DC = 1.6; VDD = 3.3; VIN_AC = 1; VIN_DC = 0; F0 = 3.3; F1 = 3.3; F2 = 0; S0 = 3.3; S1 = 0; S2 = 0; VCM_AMP = 0
    Outputs: VOUT_V [V]; d2_VOUT_dB; d2_VLF2_dB; d2_VGA_dB; d2_VLF1_dB; d2_VIA_dB
  IN_MC (off): FECG/fecg_tb/schematic, simulator spectre
    Variables: VIN_FREQ = 50; VIN_AMP = 0; FC = 4k; VCM_AC = 0; VCM_DC = 1.6; VDD = 3.3; VIN_AC = 1; VIN_DC = 50m; F0 = 3.3; F1 = 3.3; F2 = 0; S0 = 3.3; S1 = 0; S2 = 0; VCM_AMP = 0.1
    Outputs: VOUT_V [V]; d2_VOUT_dB; d2_VLF2_dB; d2_VGA_dB; d2_VLF1_dB; d2_VIA_dB
  NOISE_CMRR (off): FECG/fecg_tb/schematic, simulator spectre
    Variables: VIN_FREQ = 50; VIN_AMP = 0; FC = 4k; VCM_AC = 0; VCM_DC = 1.5; VDD = 3.3; VIN_AC = 1; VIN_DC = 0; F0 = 3.3; F1 = 3.3; F2 = 0; S0 = 3.3; S1 = 0; S2 = 0
    Outputs: Output_noise_Vrms; CM_Gain_dB; DIFF_Gain_dB; CMRR_50Hz_dB; Input_referred_noise_Vrms; DIFF_Gain; CM_Gain; CM_Gain_db
  NOISE_CMRR_MC (off): FECG/fecg_tb/schematic, simulator spectre
    Variables: VIN_FREQ = 50; VIN_AMP = 0; FC = 4k; VCM_AC = 0; VCM_DC = 1.5; VDD = 3.3; VIN_AC = 1; VIN_DC = 150m; F0 = 3.3; F1 = 3.3; F2 = 0; S0 = 3.3; S1 = 0; S2 = 0
    Outputs: Output_noise_Vrms; CM_Gain_dB; DIFF_Gain_dB; CMRR_50Hz_dB; Input_referred_noise_Vrms; DIFF_Gain; CM_Gain; CM_Gain_db
Corners (all switched off):
  model folders: /opt/pdk/ams/410/spectre/c35
  every corner: /opt/pdk/ams/410/spectre/c35/processOption.scs, /opt/pdk/ams/410/spectre/c35/cmos53.scs[cmoswo cmoswp cmosws cmoswz], /opt/pdk/ams/410/spectre/c35/bip.scs[biptm], /opt/pdk/ams/410/spectre/c35/ind.scs[indtm], /opt/pdk/ams/410/spectre/c35/esddiode.scs[esddiodetm]
  CMOS (off): res.scs[restm], cap.scs[captm]
  CMOS_VDD (off): VDD=2.97 3.63; res.scs[restm], cap.scs[captm]
  CMOS_VDD_TEMP (off): temperature=-40 85; VDD=2.97 3.63; res.scs[restm], cap.scs[captm]
  CMOS_RES_CAP_VDD_TEMP: temperature=-40 85; VDD=2.97 3.63; res.scs[reswp resws], cap.scs[capwp capws]
  CMOS_RES_CAP_TEMP (off): temperature=-40 85; res.scs[reswp resws], cap.scs[capwp capws]
Specs:
  IN / VOUT_V: > 1
  IN / d2_VOUT_dB: > 60
  IN_MC / VOUT_V: > 1
  IN_MC / d2_VOUT_dB: > 60
  NOISE_CMRR / Input_referred_noise_Vrms: < 1u
  NOISE_CMRR_MC / Input_referred_noise_Vrms: < 1u
