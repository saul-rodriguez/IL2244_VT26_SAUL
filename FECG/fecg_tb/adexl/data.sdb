ADE simulation setup
Run mode: Monte Carlo Sampling
Tests:
  VIN (off): FECG/fecg_tb/schematic, simulator spectre
    Outputs: /I2/INT; V_OUT; V_OUT_dB; d2_dB; total_out_noise_pss
  Noise (off): FECG/fecg_tb/schematic, simulator spectre
    Outputs: transient_noise; /I2/INT; total_out_noise_pss
  MC (off): FECG/fecg_tb/schematic, simulator spectre
    Outputs: /I2/INT; V_OUT; V_OUT_dB; d2_dB
Global variables:
  VCM_AC = 1
  VCM_DC = 1.6
  VDD = 3.3
  VIN_AC = 1
  VIN_DC = 0 (off)
  FC = 4k (off)
  VIN_AMP = 0 (off)
  VIN_FREQ = 0 (off)
  S0 = 3.3
  S1 = 3.3
  S2 = 0
  T0 = 0
  T1 = 0
  T2 = 0
  VDD_STEP = 0
  VIN_STEP = 0
Corners (all switched off):
  model folders: /opt/pdk/ams/410/spectre/c35
  every corner: /opt/pdk/ams/410/spectre/c35/processOption.scs, /opt/pdk/ams/410/spectre/c35/cmos53.scs[cmoswo cmoswp cmosws cmoswz], /opt/pdk/ams/410/spectre/c35/bip.scs[biptm], /opt/pdk/ams/410/spectre/c35/ind.scs[indtm], /opt/pdk/ams/410/spectre/c35/esddiode.scs[esddiodetm]
  CMOS (off): res.scs[restm], cap.scs[captm]
  CMOS_VDD (off): VDD=2.97 3.63; res.scs[restm], cap.scs[captm]
  CMOS_VDD_TEMP (off): temperature=-40 85; VDD=2.97 3.63; res.scs[restm], cap.scs[captm]
  CMOS_RES_CAP_VDD_TEMP: temperature=-40 85; VDD=2.97 3.63; res.scs[reswp resws], cap.scs[capwp capws]
Monte Carlo Sampling options: mcmethod=all, mcnumpoints=2, parasiticanalysis=0
