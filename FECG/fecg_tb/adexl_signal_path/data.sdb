ADE simulation setup
Run mode: Single Run, Sweeps and Corners
Tests:
  IN (off): FECG/fecg_tb/schematic, simulator spectre
    Outputs: d2_VOUT_db; d2_VIA_db; d2_VLF1_db; d2_VGA_db; d2_VLF2_db; CMRR
  Noise_CMRR: FECG/fecg_tb/schematic, simulator spectre
    Outputs: Output_Noise_Vrms; Gain; CM_Gain_dB_50; DIF_Gain_dB_50; CMRR_dB; DIF_Gain; Input_ref_noise_Vrms
Global variables:
  VIN_FREQ = 50 (off)
  VIN_AMP = 0.8m (off)
  FC = 4K
  VCM_AC = 0
  VCM_DC = 1.6
  VDD = 3.3
  VIN_AC = 1
  VIN_DC = 50m
  S0 = 3.3
  S1 = 3.3
  S2 = 3.3
Specs:
  Noise_CMRR / CMRR_dB: > 90
  Noise_CMRR / Input_ref_noise_Vrms: < 1e-6
