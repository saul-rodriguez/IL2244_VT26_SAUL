ADE simulation setup
Run mode: Monte Carlo Sampling
Tests:
  IN (off): FECG/fecg_tb/schematic, simulator spectre
    Outputs: d2_VOUT_db; d2_VIA_db; d2_VLF1_db; d2_VGA_db; d2_VLF2_db; CMRR
  Noise_CMRR (off): FECG/fecg_tb/schematic, simulator spectre
    Outputs: Output_Noise_Vrms; Gain; CM_Gain_dB_50; DIF_Gain_dB_50; CMRR_dB; DIF_Gain; Input_ref_noise_Vrms
  IN_MC: FECG/fecg_tb/schematic, simulator spectre
    Outputs: d2_VOUT_db; d2_VIA_db; d2_VLF1_db; d2_VGA_db; d2_VLF2_db; CMRR
Global variables:
  VIN_FREQ = 50 (off)
  VIN_AMP = 1m (off)
  FC = 4K
  VCM_AC = 0
  VCM_DC = 1.5
  VDD = 3.3
  VIN_AC = 1
  VIN_DC = 50m
  S0 = 3.3
  S1 = 0
  S2 = 0
  F0 = 3.3
  F1 = 3.3
  F2 = 0
Corners (all switched off):
  model folders: /opt/pdk/ams/410/spectre/c35
  every corner: /opt/pdk/ams/410/spectre/c35/processOption.scs, /opt/pdk/ams/410/spectre/c35/cmos53.scs[cmoswo cmoswp cmosws cmoswz], /opt/pdk/ams/410/spectre/c35/bip.scs[biptm], /opt/pdk/ams/410/spectre/c35/ind.scs[indtm], /opt/pdk/ams/410/spectre/c35/esddiode.scs[esddiodetm]
  CMOS (off): res.scs[restm], cap.scs[captm]
  CMOS_VDD (off): VDD=2.97 3.63; res.scs[restm], cap.scs[captm]
  CMOS_VDD_TEMP (off): temperature=-40 85; VDD=2.97 3.63; res.scs[restm], cap.scs[captm]
  CMOS_RES_CAP_VDD_TEMP (off): temperature=-40 85; VDD=2.97 3.63; res.scs[reswp resws], cap.scs[capwp capws]
  CMOS_RES_CAP_TEMP: temperature=-40 85; res.scs[reswp resws], cap.scs[capwp capws]
Specs:
  Noise_CMRR / CMRR_dB: > 90
  Noise_CMRR / Input_ref_noise_Vrms: < 1e-6
Monte Carlo Sampling options: mcmethod=all, mcnumpoints=100, parasiticanalysis=0
