ADE simulation setup
Test PSS_VIN: FECG/fecg_front_end_tb/schematic, simulator spectre
  Models: /opt/pdk/ams/410/spectre/c35/processOption.scs, /opt/pdk/ams/410/spectre/c35/cmos53.scs[cmostm], /opt/pdk/ams/410/spectre/c35/res.scs[restm], /opt/pdk/ams/410/spectre/c35/cap.scs[captm], /opt/pdk/ams/410/spectre/c35/bip.scs[biptm], /opt/pdk/ams/410/spectre/c35/ind.scs[indtm], /opt/pdk/ams/410/spectre/c35/esddiode.scs[esddiodetm]
  Variables: F0 = 3.3; F1 = 3.3; F2 = 0; S0 = 1; S1 = 0; S2 = 0; VCM_AMP = 0; VIN_FREQ = 50; VIN_AMP = 0.8m; FC = 4k; VCM_AC = 0; VCM_DC = 1.5; VDD = 3.3; VIN_AC = 1; VIN_DC = 0
  Temperature: 27
  Simulator options: reltol=100e-6 homotopy=all limit=delta additionalArgs=enable_pre_ver=yes ignorezerovar=yes
  Files: definitions /opt/pdk/ams/410/spectre/c35/soac/soac.scs
  Analysis pss: engine=Shooting fund=50 harms=10 errpreset=conservative
  Analysis dc: (saves the operating point)
  Output v /I19/VIA; pss (V) = vtime('pss "/I19/VIA")
  Output v /I19/VLF1; pss (V) = vtime('pss "/I19/VLF1")
  Output v /I19/VGA; pss (V) = vtime('pss "/I19/VGA")
  Output v /I19/VLF2; pss (V) = vtime('pss "/I19/VLF2")
  Output v /VOUT; pss (V) = vtime('pss "/VOUT")
  Output v /VOUT; pss dB20(V) = db(vh('pss "/VOUT"))
  Output VIA_d2_dB = (harmonic(db(vh('pss "/I19/VIA")) 1) - harmonic(db(vh('pss "/I19/VIA")) 2))
  Output VLF1_d2_dB = (harmonic(db(vh('pss "/I19/VLF1")) 1) - harmonic(db(vh('pss "/I19/VLF1")) 2))
  Output VGA_d2_dB = (harmonic(db(vh('pss "/I19/VGA")) 1) - harmonic(db(vh('pss "/I19/VGA")) 2))
  Output VLF2_d2_dB1 = (harmonic(db(vh('pss "/I19/VLF2")) 1) - harmonic(db(vh('pss "/I19/VLF2")) 2))
  Output VOUT_d2_dB = (harmonic(db(vh('pss "/VOUT")) 1) - harmonic(db(vh('pss "/VOUT")) 2))
  Output VOUT_V = harmonic(mag(vh('pss "/VOUT")) 1)
