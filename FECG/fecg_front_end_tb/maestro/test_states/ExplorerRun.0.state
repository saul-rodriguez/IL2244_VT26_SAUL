ADE simulation setup
Test PSS_VIN: FECG/fecg_front_end_tb/schematic, simulator spectre
  Models: /opt/pdk/ams/410/spectre/c35/soac/processOption.scs, /opt/pdk/ams/410/spectre/c35/soac/cmos53.scs[cmostm], /opt/pdk/ams/410/spectre/c35/soac/res.scs[restm], /opt/pdk/ams/410/spectre/c35/soac/cap.scs[captm], /opt/pdk/ams/410/spectre/c35/soac/bip.scs[biptm], /opt/pdk/ams/410/spectre/c35/soac/ind.scs[indtm], /opt/pdk/ams/410/spectre/c35/soac/esddiode.scs[esddiodetm]
  Variables: F0 = 3.3; F1 = 3.3; F2 = 0; S0 = 1; S1 = 0; S2 = 0; VCM_AMP = 1; VIN_FREQ = 50; VIN_AMP = 10m; FC = 2K; VCM_AC = 0; VCM_DC = 1.5; VDD = 3.3; VIN_AC = 1; VIN_DC = 10m
  Temperature: 27
  Simulator options: reltol=100e-6 homotopy=all limit=delta additionalArgs=enable_pre_ver=yes ignorezerovar=yes
  Files: definitions /opt/pdk/ams/410/spectre/c35/soac/soac.scs
  Analysis dc: (saves the operating point)
