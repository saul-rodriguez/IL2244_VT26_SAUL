ADE simulation setup
Run mode: Single Run, Sweeps and Corners
Tests:
  FECG_fecg_cmfb_tb_1: FECG/fecg_cmfb_tb/schematic, simulator spectre
    Variables: Ce_sg = 5p; Csg_tg = 10p; RL = 0; VREF = 1.0; VS_CM = 14.14; VREF_PULSE = 0; EN_CMFB = 3.3
    Outputs: /INN; /INP; /CMFB; /CM; (VT("/INP") - VT("/INN")); CM_amplitude
  STAB (off): FECG/fecg_cmfb_tb/schematic, simulator spectre
    Variables: Ce_sg = 5p; Csg_tg = 10p; RL = 51k; VREF = 1; VS_CM = 0; VREF_PULSE = 10m
    Outputs: /INN; /INP; /CMFB; /CM
Global variables:
  Ce_sg = 30p
  Csg_tg = 5p
  RL = 51k
