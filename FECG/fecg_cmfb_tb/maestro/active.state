ADE simulation setup
Test STAB: FECG/fecg_cmfb_tb/schematic, simulator spectre
  Models: /opt/pdk/ams/410/spectre/c35/processOption.scs, /opt/pdk/ams/410/spectre/c35/cmos53.scs[cmostm], /opt/pdk/ams/410/spectre/c35/res.scs[restm], /opt/pdk/ams/410/spectre/c35/cap.scs[captm], /opt/pdk/ams/410/spectre/c35/bip.scs[biptm], /opt/pdk/ams/410/spectre/c35/ind.scs[indtm], /opt/pdk/ams/410/spectre/c35/esddiode.scs[esddiodetm]
  Variables: VREF_PULSE = 10m; VS_CM = 0; Ce_sg = 5p; Csg_tg = 10p; RL = 51k; VREF = 1
  Temperature: 27
  Simulator options: reltol=100e-6 homotopy=all limit=delta additionalArgs=enable_pre_ver=yes ignorezerovar=yes
  Files: definitions /opt/pdk/ams/410/spectre/c35/soac/soac.scs
  Analysis pz: p=/INP iprobe=/V7 freq=1
  Analysis tran: stop=150u errpreset=conservative
  Analysis dc: (saves the operating point)
  Output Poles = pzFrequencyAndRealFilter(getData("poles" ?result "pz"))
  Signals: /INN, /INP, /CMFB
Test FECG_fecg_cmfb_tb_1: FECG/fecg_cmfb_tb/schematic, simulator spectre
  Models: /opt/pdk/ams/410/spectre/c35/processOption.scs, /opt/pdk/ams/410/spectre/c35/cmos53.scs[cmostm], /opt/pdk/ams/410/spectre/c35/res.scs[restm], /opt/pdk/ams/410/spectre/c35/cap.scs[captm], /opt/pdk/ams/410/spectre/c35/bip.scs[biptm], /opt/pdk/ams/410/spectre/c35/ind.scs[indtm], /opt/pdk/ams/410/spectre/c35/esddiode.scs[esddiodetm]
  Variables: VREF_PULSE = 0; VS_CM = 14.14; Ce_sg = 5p; Csg_tg = 10p; RL = 0; VREF = 1
  Temperature: 27
  Simulator options: reltol=100e-6 homotopy=all limit=delta additionalArgs=enable_pre_ver=yes ignorezerovar=yes
  Files: definitions /opt/pdk/ams/410/spectre/c35/soac/soac.scs
  Analysis pz: p=/INP iprobe=/V7 freq=1
  Analysis tran: stop=80m errpreset=conservative
  Analysis dc: (saves the operating point)
  Output Poles = pzFrequencyAndRealFilter(getData("poles" ?result "pz"))
  Output (VT("/INP") - VT("/INN"))
  Output CM_amplitude = (peakToPeak(((VT("/INN") + VT("/INP")) / 2)) / 2)
  Signals: /INN, /INP, /CMFB, /CM
Run mode: Single Run, Sweeps and Corners
Global variables:
  Ce_sg = 30p
  Csg_tg = 5p
  RL = 51k
Setup values for test FECG_fecg_cmfb_tb_1: VREF = 1.0; EN_CMFB = 3.3
Disabled tests: FECG_fecg_cmfb_tb_1_1, STAB
