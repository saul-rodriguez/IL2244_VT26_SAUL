ADE simulation setup
Run mode: Monte Carlo Sampling
Tests:
  TRAN_CMRR (off): FECG/fecg_front_end_cmrr_tb/schematic, simulator spectre
    Variables: VIN_FREQ = 50; VIN_AMP = 0; FC = 4k; VCM_AC = 0; VDD = 3.3; VIN_AC = 1; VIN_DC = 10m; Ce_sg = 5p; Csg_tg = 10p; F0 = 3.3; F1 = 3.3; F2 = 0; RL = 0; S0 = 3.3; S1 = 0; S2 = 0; VS_CM = 14.14
    Outputs: /VINP; /VINN; /CMFB; /VOUT; CM_DIFF_IN
  TRAN_CMRR_MC: FECG/fecg_front_end_cmrr_tb/schematic, simulator spectre
    Variables: VIN_FREQ = 50; VIN_AMP = 0; FC = 4k; VCM_AC = 0; VDD = 3.3; VIN_AC = 1; VIN_DC = 10m; Ce_sg = 5p; Csg_tg = 10p; F0 = 3.3; F1 = 3.3; F2 = 0; RL = 0; S0 = 3.3; S1 = 0; S2 = 0; VS_CM = 14.14
    Outputs: /VINP; /VINN; /CMFB; /VOUT; CM_DIFF_IN; VOUT_50Hz_Vrms; VOUT_DC
Global variables:
  Ce_sg = 10p
  Csg_tg = 10p
  VS_CM = 14.14
  RL = 51k
  VIN_OFF_DC = 300m
Monte Carlo Sampling options: mismatchvary=Gaussian, sssnumpoints=7000, mismatchscale=1, processscale=1, pointsPerJobPolicy=Group automatically, maxPointsPerJob=10, reliabilitymode=singlestress, wcdinitialpoints=200, mcnumpoints=100, yeyistostart=3.0, mcSigmaTarget=3, yeiterations=10, processvary=Gaussian, yeexpectedyield=3, mcmethod=all, yeusehistorymc=0, yeuseautomcsamples=1, yecreatecorners=0, mcdistandscalingmismatchenable=0, parasiticanalysis=0, mcFilterPluginEnabled=0, haveyeyieldtostart=1, yeusevarreduction=1, mcdistandscalingprocessenable=0
