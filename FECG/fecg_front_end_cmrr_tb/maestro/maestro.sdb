ADE simulation setup
Run mode: Single Run, Sweeps and Corners
Tests:
  TRAN_CMRR: FECG/fecg_front_end_cmrr_tb/config, simulator spectre
    Variables: VIN_FREQ = 50; VIN_AMP = 0; FC = 500; VCM_AC = 0; VDD = 3.3; VIN_AC = 1; VIN_DC = 10m; Ce_sg = 5p; Csg_tg = 10p; F0 = 3.3; F1 = 3.3; F2 = 0; RL = 0; S0 = 3.3; S1 = 0; S2 = 0; VS_CM = 14.14; VCM_DC = 1.6; EN_CMFB = 3.3
    Outputs: /VINP; /VINN; /CMFB; /VOUT; CM_DIFF_IN
  TRAN_CMRR_MC (off): FECG/fecg_front_end_cmrr_tb/config, simulator spectre
    Variables: VIN_FREQ = 50; VIN_AMP = 0; FC = 500; VCM_AC = 0; VDD = 3.3; VIN_AC = 1; VIN_DC = 10m; Ce_sg = 5p; Csg_tg = 10p; F0 = 3.3; F1 = 3.3; F2 = 0; RL = 0; S0 = 3.3; S1 = 0; S2 = 0; VS_CM = 14.14; VCM_DC = 1.6; EN_CMFB = 3.3
    Outputs: /VINP; /VINN; /CMFB; /VOUT; CM_DIFF_IN; VOUT_50Hz_Vrms; VOUT_DC
Global variables:
  Ce_sg = 10p
  Csg_tg = 10p
  VS_CM = 14.14
  RL = 0
  VIN_OFF_DC = 300m
  EN_CMFB = 3.3
