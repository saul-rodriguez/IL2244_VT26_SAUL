ADE simulation setup
Test FECG_fecg_front_end_cmrr_tb_1: FECG/fecg_front_end_cmrr_tb/schematic, simulator spectre
  Models: /opt/pdk/ams/410/spectre/c35/processOption.scs, /opt/pdk/ams/410/spectre/c35/cmos53.scs[cmostm], /opt/pdk/ams/410/spectre/c35/res.scs[restm], /opt/pdk/ams/410/spectre/c35/cap.scs[captm], /opt/pdk/ams/410/spectre/c35/bip.scs[biptm], /opt/pdk/ams/410/spectre/c35/ind.scs[indtm], /opt/pdk/ams/410/spectre/c35/esddiode.scs[esddiodetm]
  Variables: Ce_sg = 5p; Csg_tg = 10p; F0 = 3.3; F1 = 3.3; F2 = 0; RL = 0; S0 = 3.3; S1 = 0; S2 = 0; VS_CM = 14.14; VIN_FREQ = 50; VIN_AMP = 0; FC = 4k; VCM_AC = 0; VDD = 3.3; VIN_AC = 1; VIN_DC = 10m
  Temperature: 27
  Simulator options: reltol=100e-6 homotopy=all limit=delta additionalArgs=enable_pre_ver=yes ignorezerovar=yes
  Files: definitions /opt/pdk/ams/410/spectre/c35/soac/soac.scs
  Analysis dc: (saves the operating point)
