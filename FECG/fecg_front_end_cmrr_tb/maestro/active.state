ADE simulation setup
Test FECG_fecg_front_end_cmrr_tb_1: FECG/fecg_front_end_cmrr_tb/schematic, simulator spectre
  Models: /opt/pdk/ams/410/spectre/c35/processOption.scs, /opt/pdk/ams/410/spectre/c35/cmos53.scs[cmostm], /opt/pdk/ams/410/spectre/c35/res.scs[restm], /opt/pdk/ams/410/spectre/c35/cap.scs[captm], /opt/pdk/ams/410/spectre/c35/bip.scs[biptm], /opt/pdk/ams/410/spectre/c35/ind.scs[indtm], /opt/pdk/ams/410/spectre/c35/esddiode.scs[esddiodetm]
  Variables: Ce_sg = 5p; Csg_tg = 10p; F0 = 3.3; F1 = 3.3; F2 = 0; RL = 0; S0 = 3.3; S1 = 0; S2 = 0; VS_CM = 14.14; VIN_FREQ = 50; VIN_AMP = 0; FC = 4k; VCM_AC = 0; VDD = 3.3; VIN_AC = 1; VIN_DC = 10m
  Temperature: 27
  Simulator options: reltol=100e-6 homotopy=all limit=delta additionalArgs=enable_pre_ver=yes ignorezerovar=yes
  Files: definitions /opt/pdk/ams/410/spectre/c35/soac/soac.scs
  Analysis tran: stop=100m errpreset=conservative
  Analysis dc: (saves the operating point)
  Output CM_DIFF_IN = (VT("/VINP") - VT("/VINN"))
  Signals: /VINP, /VINN, /CMFB, /VOUT
Test TRAN_CMRR_MC: FECG/fecg_front_end_cmrr_tb/schematic, simulator spectre
  Models: /opt/pdk/ams/410/spectre/c35/processOption.scs, /opt/pdk/ams/410/spectre/c35/cmos53.scs[cmosmc], /opt/pdk/ams/410/spectre/c35/res.scs[resmc], /opt/pdk/ams/410/spectre/c35/cap.scs[capmc], /opt/pdk/ams/410/spectre/c35/bip.scs[bipmc], /opt/pdk/ams/410/spectre/c35/ind.scs[indmc], /opt/pdk/ams/410/spectre/c35/esddiode.scs[esddiodemc]
  Variables: Ce_sg = 5p; Csg_tg = 10p; F0 = 3.3; F1 = 3.3; F2 = 0; RL = 0; S0 = 3.3; S1 = 0; S2 = 0; VS_CM = 14.14; VIN_FREQ = 50; VIN_AMP = 0; FC = 4k; VCM_AC = 0; VDD = 3.3; VIN_AC = 1; VIN_DC = 10m
  Temperature: 27
  Simulator options: reltol=100e-6 homotopy=all limit=delta additionalArgs=enable_pre_ver=yes ignorezerovar=yes
  Files: definitions /opt/pdk/ams/410/spectre/c35/soac/soac.scs
  Analysis dc: (saves the operating point)
  Analysis pss: engine=Shooting fund=50 harms=20 errpreset=conservative
  Output CM_DIFF_IN = (VT("/VINP") - VT("/VINN"))
  Output v /VOUT; pss (V) = vtime('pss "/VOUT")
  Output v /VINN; pss (V) = vtime('pss "/VINN")
  Output v /VINP; pss (V) = vtime('pss "/VINP")
  Output v /CMFB; pss (V) = vtime('pss "/CMFB")
  Output VOUT_50Hz_Vrms = harmonic(mag(vh('pss "/VOUT")) 1)
  Output VOUT_DC = harmonic(mag(vh('pss "/VOUT")) 0)
  Signals: /VINP, /VINN, /CMFB, /VOUT
Test TRAN_CMRR: FECG/fecg_front_end_cmrr_tb/schematic, simulator spectre
  Models: /opt/pdk/ams/410/spectre/c35/processOption.scs, /opt/pdk/ams/410/spectre/c35/cmos53.scs[cmostm], /opt/pdk/ams/410/spectre/c35/res.scs[restm], /opt/pdk/ams/410/spectre/c35/cap.scs[captm], /opt/pdk/ams/410/spectre/c35/bip.scs[biptm], /opt/pdk/ams/410/spectre/c35/ind.scs[indtm], /opt/pdk/ams/410/spectre/c35/esddiode.scs[esddiodetm]
  Variables: Ce_sg = 5p; Csg_tg = 10p; F0 = 3.3; F1 = 3.3; F2 = 0; RL = 0; S0 = 3.3; S1 = 0; S2 = 0; VS_CM = 14.14; VIN_FREQ = 50; VIN_AMP = 0; FC = 4k; VCM_AC = 0; VDD = 3.3; VIN_AC = 1; VIN_DC = 0
  Temperature: 27
  Simulator options: reltol=100e-6 homotopy=all limit=delta additionalArgs=enable_pre_ver=yes ignorezerovar=yes
  Files: definitions /opt/pdk/ams/410/spectre/c35/soac/soac.scs
  Analysis tran: stop=500m errpreset=conservative
  Analysis dc: (saves the operating point)
  Analysis pss: engine=Shooting fund=50 harms=20 errpreset=conservative
  Output CM_DIFF_IN = (VT("/VINP") - VT("/VINN"))
  Output v /VOUT; pss (V) = vtime('pss "/VOUT")
  Output v /VINN; pss (V) = vtime('pss "/VINN")
  Output v /VINP; pss (V) = vtime('pss "/VINP")
  Output v /CMFB; pss (V) = vtime('pss "/CMFB")
  Signals: /VINP, /VINN, /CMFB, /VOUT
