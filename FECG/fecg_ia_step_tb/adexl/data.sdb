ADE simulation setup
Run mode: Single Run, Sweeps and Corners
Tests:
  VIN (off): FECG/fecg_ia_step_tb/schematic, simulator spectre
  VDD (off): FECG/fecg_ia_step_tb/schematic, simulator spectre
  VIN_SHORT: FECG/fecg_ia_step_tb/schematic, simulator spectre
Global variables:
  FC = 4k (off)
  VCM_AC = 0
  VCM_AMP = 0
  VCM_DC = 1.6
  VDD = 0 (off)
  VIN_AC = 1
  VIN_AMP = 0 (off)
  VIN_DC = 0
  VIN_FREQ = 50
  VIN_PULSE = 0 (off)
  VDD_PULSE = 3.3 (off)
  VDD_PULSE_RT = 1u (off)
Corners:
  model folders: /opt/pdk/ams/410/spectre/c35
  every corner: /opt/pdk/ams/410/spectre/c35/processOption.scs, /opt/pdk/ams/410/spectre/c35/cmos53.scs[cmoswo cmoswp cmosws cmoswz], /opt/pdk/ams/410/spectre/c35/bip.scs[biptm], /opt/pdk/ams/410/spectre/c35/ind.scs[indtm], /opt/pdk/ams/410/spectre/c35/esddiode.scs[esddiodetm]
  CMOS (off): res.scs[restm], cap.scs[captm]
  CMOS_VDD (off): res.scs[restm], cap.scs[captm]
  CMOS_VDD_TEMP (off): temperature=-40 85; res.scs[restm], cap.scs[captm]
  CMOS_RES_CAP_VDD_TEMP: temperature=-40 85; VDD=2.97 3.63; res.scs[reswp resws], cap.scs[capwp capws]
